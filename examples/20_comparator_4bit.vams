// Multi-module comparison: a 4-bit magnitude comparator built as a chain of
// single-bit comparator slices, MSB -> LSB. Each slice takes the running
// (greater, equal) decision from the more-significant slice and refines it:
//   gt_out = gt_in OR (eq_in AND a_i AND NOT b_i)
//   eq_out = eq_in AND (a_i == b_i)
// The decision ripples down four module boundaries. EXHAUSTIVE over all
// 16 x 16 = 256 (a, b) pairs, asserting both `a > b` and `a == b`.
`include "disciplines.vams"

module BitDriver (output logic q);
    parameter real level = 0.0;
    always @(*) begin
        q <= (level > 0.5);
    end
endmodule

module CmpSlice (input logic ai, input logic bi,
                 input logic gt_in, input logic eq_in,
                 output logic gt_out, output logic eq_out);
    always @(*) begin
        gt_out <= gt_in || (eq_in && (ai && !bi));
        eq_out <= eq_in && (ai == bi);
    end
endmodule

module Comparator4 ();
    logic a0, a1, a2, a3;
    logic b0, b1, b2, b3;
    // Running decision down the chain (MSB slice first).
    logic g3, e3, g2, e2, g1, e1;
    logic gt, eq;
    // Head constants: gt_in = 0, eq_in = 1 into the MSB slice.
    logic zero;
    logic one;

    BitDriver dz  (.q(zero));
    BitDriver #(.level(1.0)) do1 (.q(one));
    BitDriver da0 (.q(a0));
    BitDriver da1 (.q(a1));
    BitDriver da2 (.q(a2));
    BitDriver da3 (.q(a3));
    BitDriver db0 (.q(b0));
    BitDriver db1 (.q(b1));
    BitDriver db2 (.q(b2));
    BitDriver db3 (.q(b3));

    CmpSlice s3 (.ai(a3), .bi(b3), .gt_in(zero), .eq_in(one), .gt_out(g3), .eq_out(e3));
    CmpSlice s2 (.ai(a2), .bi(b2), .gt_in(g3),    .eq_in(e3),  .gt_out(g2), .eq_out(e2));
    CmpSlice s1 (.ai(a1), .bi(b1), .gt_in(g2),    .eq_in(e2),  .gt_out(g1), .eq_out(e1));
    CmpSlice s0 (.ai(a0), .bi(b0), .gt_in(g1),    .eq_in(e1),  .gt_out(gt), .eq_out(eq));
endmodule
