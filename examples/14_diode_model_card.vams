// SPICE-style model cards, migrated to plain Verilog-A.
//
// MD-45 NOTE (2026-08-13): the original PHDL file demonstrated Piperine's
// value-layer surface — `bundle DiodeModel`, `capability Junction`, an
// `impl Junction for DiodeModel`, and a `param model : Junction` whose
// default was a bundle literal. Verilog-AMS Annex A has no productions for
// any of those constructs (no bundle, no capability, no impl, no
// bounded-polymorphism on params); MD-45 records the whole value-layer
// surface as deleted at T21. The migration is faithful at the level the
// python twin actually tests — a diode with two stageable physics
// parameters (`model_isat`/`model_vt`) — and drops the capability
// indirection that was PHDL's demonstration of the (now-removed)
// declared-language-surface feature. The python twin's `m.set("d1",
// "model_isat", 1e-12)` works identically: `model_isat` is a plain
// parameter on the Diode module, and the staged override reaches it
// directly (no `Junction::current` dispatch in between).
`include "disciplines.vams"

module Diode (inout electrical a, inout electrical c);
    // The DiodeModel bundle's two fields, flattened to ordinary parameters
    // (same flattening convention T41/T42 applied to ngspice model cards).
    parameter real model_isat = 1e-14;   // saturation current, A
    parameter real model_vt   = 0.02585; // thermal voltage, V
    analog begin
        // Shockley law, formerly `model.current(V(a,c))` — the literal
        // expression the deleted `impl Junction for DiodeModel` carried.
        I(a, c) <+ model_isat * (exp(V(a, c) / model_vt) - 1.0);
    end
endmodule

module VoltageSource (inout electrical p, inout electrical n);
    parameter real voltage = 5.0;
    analog begin
        V(p, n) <+ voltage;
    end
endmodule

module Resistor (inout electrical p, inout electrical n);
    parameter real r = 1e3;
    analog begin
        I(p, n) <+ V(p, n) / r;
    end
endmodule

module BiasCell ();
    electrical gnd;
    electrical vin;
    electrical out;
    VoltageSource #(.voltage(5.0)) src (.p(vin), .n(gnd));
    Resistor #(.r(1e3)) rb (.p(vin), .n(out));
    Diode d1 (.a(out), .c(gnd));
endmodule
