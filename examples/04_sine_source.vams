// Time-domain sine source built on `$abstime`, loaded by a resistor.
// The python twin validates the waveform numerically — amplitude at the quarter
// period, RMS = A/sqrt(2), zero mean, first rising zero-crossing at one full
// period — and `$display`s the sampled table plus the DC operating point.
`include "disciplines.vams"

// v(t) = A·sin(2*pi*f*t)
module SineSource (inout electrical p, inout electrical n);
    parameter real amplitude = 2.0;
    parameter real freq = 1e3;
    analog begin
        V(p, n) <+ amplitude * sin(6.283185307179586 * freq * $abstime);
    end
endmodule

module Resistor (inout electrical p, inout electrical n);
    parameter real r = 1e3;
    analog begin
        I(p, n) <+ V(p, n) / r;
    end
endmodule

module SineDemo ();
    electrical gnd;
    electrical out;
    electrical mid;
    SineSource #(.amplitude(2.0), .freq(1e3)) src (.p(out), .n(gnd));
    Resistor #(.r(1e3)) r_top (.p(out), .n(mid));
    Resistor #(.r(1e3)) r_load (.p(mid), .n(gnd));
endmodule
