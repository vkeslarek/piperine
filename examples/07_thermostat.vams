// Bang-bang thermostat: a thermal RC plant (ambient 20 C, tau = 10 ms in
// simulation seconds) heated by a controlled source; `@above` events flip
// the heater off at 25 C and back on at 22 C. The python twin uses a
// delayed-start transient (`TranConfig.start`) to skip the warm-up and
// asserts the steady limit cycle stays inside the hysteresis band.
`include "disciplines.vams"

// Heat capacity + leak to ambient: 1 V == 1 C.
module ThermalPlant (inout electrical temp, inout electrical gnd);
    parameter real tamb = 20.0;
    parameter real rth = 10.0;     // C per W
    parameter real cth = 1e-3;     // tau = rth*cth = 10 ms
    analog begin
        I(temp, gnd) <+ cth * ddt(V(temp, gnd));
        I(temp, gnd) <+ (V(temp, gnd) - tamb) / rth;
    end
endmodule

// The controller injects heat while `heater` is on; the events implement
// the hysteresis comparator. `heater` is persistent analog state
// (Verilog-A module-scope `real`): seeded once at `initial_step`, then
// flipped only by the `above` events.
module Controller (inout electrical temp, inout electrical gnd);
    parameter real t_high = 25.0;
    parameter real t_low = 22.0;
    parameter real power = 1.0;    // W -> +10 C above ambient when always-on
    real heater;
    analog begin
        @(initial_step) heater = 1.0;
        I(temp, gnd) <+ -heater * power;
        @(above(V(temp, gnd) - t_high)) heater = 0.0;
        @(above(t_low - V(temp, gnd))) heater = 1.0;
    end
endmodule

module Thermostat ();
    electrical gnd;
    electrical temp;
    ThermalPlant plant (.temp(temp), .gnd(gnd));
    Controller    ctrl  (.temp(temp), .gnd(gnd));
endmodule
