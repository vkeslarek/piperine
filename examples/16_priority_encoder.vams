// Pure digital priority encoder (the heart of an interrupt controller):
// four request lines, the highest-numbered active one wins, encoded as a
// 2-bit code plus a valid flag. The python twin reads the output logic nets
// straight off `$op` results — no analog readback stage.
`include "disciplines.vams"

module BitDriver (output logic q);
    parameter real level = 0.0;
    always @(*) begin
        q <= (level > 0.5);
    end
endmodule

module PriorityEncoder (input logic r0, input logic r1, input logic r2, input logic r3,
                        output logic y1, output logic y0, output logic valid);
    always @(*) begin
        if (r3 == 1) begin
            y1 <= 1; y0 <= 1; valid <= 1;
        end else if (r2 == 1) begin
            y1 <= 1; y0 <= 0; valid <= 1;
        end else if (r1 == 1) begin
            y1 <= 0; y0 <= 1; valid <= 1;
        end else if (r0 == 1) begin
            y1 <= 0; y0 <= 0; valid <= 1;
        end else begin
            y1 <= 0; y0 <= 0; valid <= 0;
        end
    end
endmodule

module IrqBoard ();
    logic n0, n1, n2, n3, y1, y0, ok;
    BitDriver d0 (.q(n0));
    BitDriver d1 (.q(n1));
    BitDriver d2 (.q(n2));
    BitDriver d3 (.q(n3));
    PriorityEncoder enc (.r0(n0), .r1(n1), .r2(n2), .r3(n3), .y1(y1), .y0(y0), .valid(ok));
endmodule
