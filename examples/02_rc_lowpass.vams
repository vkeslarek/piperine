// First-order RC low-pass, verified in both domains:
//  - AC: a 1 A `ac_stim` test current into R||C gives |V(f)| = R/sqrt(1+(f/fc)^2)
//    — flat passband at R, R/sqrt(2) at the corner, -20 dB/dec above it.
//  - Transient: with the node preset to 1 V through `TranConfig.ic`, the
//    free discharge follows e^(-t/tau), tau = RC.
`include "disciplines.vams"

module Resistor (inout electrical p, inout electrical n);
    parameter real r = 1e3;
    analog begin
        I(p, n) <+ V(p, n) / r;
    end
endmodule

module Capacitor (inout electrical p, inout electrical n);
    parameter real c = 100e-9;
    analog begin
        I(p, n) <+ c * ddt(V(p, n));
    end
endmodule

// A small-signal test current source: invisible at DC and in transient,
// 1 A angle 0 deg during `$ac`.
module AcProbe (inout electrical p, inout electrical n);
    analog begin
        I(p, n) <+ -ac_stim(1.0);
    end
endmodule

module RcFilter ();
    electrical gnd;
    electrical out;
    Resistor #(.r(1e3)) r1 (.p(out), .n(gnd));
    Capacitor #(.c(100e-9)) c1 (.p(out), .n(gnd));
    // fc ~= 1.5915 kHz, tau = 100 us
    AcProbe probe (.p(out), .n(gnd));
endmodule
