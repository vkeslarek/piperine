// Structural generation: a `for` loop instantiates a bank of four matched
// resistors in parallel (250 Ohm equivalent) as the bottom leg of a divider.
// v(mid) = 5 * 250/(1000+250) = 1 V, string current 4 mA split evenly.
`include "disciplines.vams"

module VoltageSource (inout electrical p, inout electrical n);
    parameter real voltage = 5.0;
    analog begin
        V(p, n) <+ voltage;
    end
endmodule

module Resistor (inout electrical p, inout electrical n);
    parameter real r = 1e3;
    analog begin
        I(p, n) <+ V(p, n) / r;
    end
endmodule

module ParallelBank ();
    electrical gnd;
    electrical top;
    electrical mid;
    genvar i;
    VoltageSource src (.p(top), .n(gnd));
    Resistor r_top (.p(top), .n(mid));
    generate
        for (i = 0; i < 4; i = i + 1) begin : bank
            Resistor r (.p(mid), .n(gnd));
        end
    endgenerate
endmodule
