// Multi-module hierarchy: a 4:1 multiplexer built as a tree of three 2:1 mux
// instances. `out = mux(mux(i0,i1,sel0), mux(i2,i3,sel0), sel1)`. The two
// leaf muxes and the root mux are separate modules wired through internal nets,
// so the test proves selection propagates correctly through two levels of
// module boundaries. EXHAUSTIVE over all 2^6 = 64 input/select combinations.
`include "disciplines.vams"

module BitDriver (output logic q);
    parameter real level = 0.0;
    always @(*) begin
        q <= (level > 0.5);
    end
endmodule

// 2:1 mux: y = sel ? b : a.
module Mux2 (input logic a, input logic b, input logic sel, output logic y);
    always @(*) begin
        y <= (a && !sel) || (b && sel);
    end
endmodule

module Mux4 ();
    logic i0, i1, i2, i3;
    logic sel0, sel1;
    logic lo, hi;
    logic out;

    BitDriver d0  (.q(i0));
    BitDriver d1  (.q(i1));
    BitDriver d2  (.q(i2));
    BitDriver d3  (.q(i3));
    BitDriver ds0 (.q(sel0));
    BitDriver ds1 (.q(sel1));

    // Level 1: two leaf muxes selected by sel0.
    Mux2 mlo  (.a(i0), .b(i1), .sel(sel0), .y(lo));
    Mux2 mhi  (.a(i2), .b(i3), .sel(sel0), .y(hi));
    // Level 2: root mux selected by sel1.
    Mux2 mroot (.a(lo), .b(hi), .sel(sel1), .y(out));
endmodule
