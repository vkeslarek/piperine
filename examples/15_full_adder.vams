// Pure digital combinational logic: a 1-bit full adder — no analog anywhere.
// The python twin sets the input drivers, runs `op` (the DC mixed-signal loop
// settles combinational logic), and reads the output Bit nets directly:
// `r.v(sum)` returns the logic value as 0/1.
`include "disciplines.vams"

// Drives a logic net from a stageable real parameter.
module BitDriver (output logic q);
    parameter real level = 0.0;
    always @(*) begin
        q <= (level > 0.5);
    end
endmodule

module FullAdder (input logic a, input logic b, input logic cin,
                  output logic sum, output logic cout);
    always @(*) begin
        sum <= (a != b) != cin;
        cout <= (a && b) || (cin && (a != b));
    end
endmodule

module AdderBoard ();
    logic na, nb, nc, nsum, ncout;
    BitDriver da (.q(na));
    BitDriver db (.q(nb));
    BitDriver dc (.q(nc));
    FullAdder fa (.a(na), .b(nb), .cin(nc), .sum(nsum), .cout(ncout));
endmodule
