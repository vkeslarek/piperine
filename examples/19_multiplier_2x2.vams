// Multi-module arithmetic: a 2-bit x 2-bit unsigned multiplier assembled from
// primitive AND-gate and half-adder modules. The partial products (four ANDs)
// feed two half-adders whose carries chain into the high bits — a small but
// real datapath spanning several module boundaries. EXHAUSTIVE over all
// 4 x 4 = 16 operand pairs, asserting p = a * b as a 4-bit result.
`include "disciplines.vams"

module BitDriver (output logic q);
    parameter real level = 0.0;
    always @(*) begin
        q <= (level > 0.5);
    end
endmodule

module And2 (input logic a, input logic b, output logic y);
    always @(*) begin
        y <= a && b;
    end
endmodule

// Half adder: sum = a XOR b, carry = a AND b.
module HalfAdder (input logic a, input logic b, output logic sum, output logic carry);
    always @(*) begin
        sum <= a != b;
        carry <= a && b;
    end
endmodule

module Mult2 ();
    logic a0, a1, b0, b1;
    // Partial products.
    logic pp00, pp01, pp10, pp11;
    // Carries between the two adder stages.
    logic c1;
    // Result bits.
    logic p0, p1, p2, p3;

    BitDriver da0 (.q(a0));
    BitDriver da1 (.q(a1));
    BitDriver db0 (.q(b0));
    BitDriver db1 (.q(b1));

    And2 g00 (.a(a0), .b(b0), .y(pp00));
    And2 g01 (.a(a0), .b(b1), .y(pp01));
    And2 g10 (.a(a1), .b(b0), .y(pp10));
    And2 g11 (.a(a1), .b(b1), .y(pp11));

    // p0 is just a0*b0 (pp00, unused as a separate output net here).
    // p1 = pp01 XOR pp10, carry c1.
    HalfAdder ha1 (.a(pp01), .b(pp10), .sum(p1), .carry(c1));
    // p2 = pp11 XOR c1, carry -> p3.
    HalfAdder ha2 (.a(pp11), .b(c1),   .sum(p2), .carry(p3));
endmodule
