// Diode clipper: a series resistor into an exponential-law diode pins the
// output near one forward drop. Exercises the Newton solve of a stiff
// nonlinearity and staged-override re-runs.
`include "disciplines.vams"

module VoltageSource (inout electrical p, inout electrical n);
    parameter real voltage = 5.0;
    analog begin
        V(p, n) <+ voltage;
    end
endmodule

module Clipper ();
    parameter real r = 1e3;
    parameter real isat = 1e-14;
    parameter real vt = 0.02585;
    electrical gnd;
    electrical drive;
    electrical out;
    VoltageSource #(.voltage(5.0)) source (.p(drive), .n(gnd));
    analog begin
        I(drive, out) <+ V(drive, out) / r;
        I(out, gnd) <+ isat * (exp(V(out, gnd) / vt) - 1.0);
    end
endmodule
