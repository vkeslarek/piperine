// 2-bit flash ADC: three analog comparators (digital block reading node
// voltages through the A2D bridge), thermometer-to-binary logic, and an
// analog reconstruction DAC so the python twin can verify the transfer staircase
// end-to-end. Thresholds at 1 V / 2 V / 3 V.
`include "disciplines.vams"

module VoltageSource (inout electrical p, inout electrical n);
    parameter real voltage = 0.0;
    analog begin
        V(p, n) <+ voltage;
    end
endmodule

module FlashAdc (input electrical vin, inout electrical gnd, inout electrical rec);
    integer q1;
    integer q0;
    real code;
    always @(*) begin
        q1 = V(vin, gnd) > 2.0;
        q0 = (V(vin, gnd) > 3.0) || ((V(vin, gnd) > 1.0) && !(V(vin, gnd) > 2.0));
        code = 0.0;
        if (q1 == 1) code = code + 2.0;
        if (q0 == 1) code = code + 1.0;
    end
    analog begin
        V(rec, gnd) <+ code;
    end
endmodule

module AdcBoard ();
    electrical gnd;
    electrical vin;
    electrical rec;
    VoltageSource #(.voltage(0.5)) src (.p(vin), .n(gnd));
    FlashAdc adc (.vin(vin), .gnd(gnd), .rec(rec));
endmodule
