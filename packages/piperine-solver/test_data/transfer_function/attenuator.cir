10:1 Voltage Attenuator - Transfer Function Test
* Piperine validation circuit
* Expected: Gain=0.0909 (1/11), R_in=11kΩ, R_out≈909Ω

V1 n_in 0 DC 1
R1 n_in n_out 10k
R2 n_out 0 1k

.tf v(n_out) V1
.end
