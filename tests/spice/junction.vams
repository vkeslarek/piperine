// Junction devices through the JIT. All four converge to their physical
// operating points:
//   - diode: pnjlim single-junction (Shockley forward drop).
//   - bjt: coupled B-E / B-C junctions, converged via gmin stepping (the
//     solver's SPICE homotopy fallback for stiff coupled junctions).
//   - mos1 / jfet: gate/channel + bulk junctions.
// The flattener's shared-temporary tape lets these large bodies compile at
// all (they used to exhaust memory); gmin stepping gets the coupled
// operating points to converge.
`include "disciplines.vams"
`include "sources.va"
`include "passives.va"
`include "diode.va"
`include "bjt.va"
`include "mos.va"
`include "jfet.va"

module DioBias ();
    electrical gnd, vin, out;
    vsrc #(.dc(5.0)) vs (.p(vin), .n(gnd));
    res  #(.r(1.0e3)) rb (.p(vin), .n(out));
    dio  d1 (.p(out), .n(gnd));
endmodule

// Diode-connected NPN (base = collector): a single effective B-E junction
// with a real KCL-consistent operating point (passes the current-residual
// convergence check). The common-emitter *amplifier* — coupled BE-forward /
// BC-reverse junctions that need saturation — is a known gap: gmin stepping
// alone converges to the wrong solution branch (active instead of saturated);
// it needs source stepping. See validation/ (bjt_ce) and the piperine ROADMAP.
module BjtDiode ();
    electrical gnd, vin, bc;
    vsrc #(.dc(5.0)) vs (.p(vin), .n(gnd));
    res  #(.r(1.0e3)) r1 (.p(vin), .n(bc));
    bjt  q1 (.c(bc), .b(bc), .e(gnd), .sub(gnd));
endmodule

// NMOS diode-connected (gate=drain): channel + bulk junctions.
module MosBias ();
    electrical gnd, vdd, d;
    vsrc #(.dc(5.0)) vd (.p(vdd), .n(gnd));
    res  #(.r(10.0e3)) r1 (.p(vdd), .n(d));
    mos1 #(.vto(1.0), .kp(2.0e-5)) m1 (.d(d), .g(d), .s(gnd), .b(gnd));
endmodule

// JFET: gate junction reverse-biased, channel conducts.
module JfetBias ();
    electrical gnd, vdd, d;
    vsrc #(.dc(5.0)) vd (.p(vdd), .n(gnd));
    res  #(.r(1.0e3)) r1 (.p(vdd), .n(d));
    jfet j1 (.d(d), .g(gnd), .s(gnd));
endmodule
