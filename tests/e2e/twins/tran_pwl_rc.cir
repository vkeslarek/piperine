* tran_pwl_rc — transient cross-check of a piecewise-linear source into the RC of tran_rc.
* The source is the host's in piperine (a node port of the top, PI-07), so there is no
* `.msl` twin and no `.command`: `source_host.rs` drives the same corners with
* `Session::source`. The cap starts discharged (`uic`). `.options interp` makes ngspice
* record on the print grid (multiples of tstep), as in tran_rc.
* Fair configuration, not retuning: the piperine run caps its step at 1e-8 (a tenth of the
* print step, the convention of every tran twin's `--max-step`), so ngspice's TMAX is set to
* the same 10n explicitly instead of its default (the print step). No tolerance changes.
V1 vin 0 PWL(0 0 2u 1 5u 1 6u 0.25)
R1 vin out 1000
C1 out 0 1.5915494309189535e-9
.options interp
.control
tran 0.1u 10u 0 10n uic
wrdata tran_pwl_rc_tran v(out)
.endc
.end
