// NMOS level 2 Id-Vds sweep — same circuit as nmos2_id_vds.cir; the
// harness stages vd.dc per sweep point and reads that source's branch current.
`include "disciplines.vams"
`include "sources.va"
`include "mos.va"

module Top ();
    electrical gnd, d, g;
    vsrc #(.dc(0.0)) vd (.p(d), .n(gnd));
    vsrc #(.dc(3.0)) vg (.p(g), .n(gnd));
    mos2 #(.l(2.0e-6), .w(10.0e-6), .vto(1.0), .kp(2.0e-5), .lambda(0.02), .rd(100.0), .rs(100.0))
        m1 (.d(d), .g(g), .s(gnd), .b(gnd));
endmodule
