`include "disciplines.vams"
`include "sources.va"
`include "passives.va"

module Top ();
    electrical gnd, vin, mid;
    vsrc #(.dc(10.0)) v1 (.p(vin), .n(gnd));
    res  #(.r(1.0e3)) r1 (.p(vin), .n(mid));
    res  #(.r(3.0e3)) r2 (.p(mid), .n(gnd));
endmodule
