// NMOS level 2 fixed gate bias, Rd load — same circuit as nmos2_fixed.cir.
`include "disciplines.vams"
`include "sources.va"
`include "passives.va"
`include "mos.va"

module Top ();
    electrical gnd, vdd, g, d;
    vsrc #(.dc(10.0)) vd (.p(vdd), .n(gnd));
    vsrc #(.dc(2.0))  vg (.p(g),   .n(gnd));
    res  #(.r(100.0e3)) r1 (.p(vdd), .n(d));
    mos2 #(.l(2.0e-6), .w(10.0e-6), .vto(1.0), .kp(2.0e-5), .lambda(0.0))
        m1 (.d(d), .g(g), .s(gnd), .b(gnd));
endmodule
