// diode I-V sweep — same circuit as diode_iv.cir; the harness stages
// v1.dc per sweep point and reads the source branch current.
`include "disciplines.vams"
`include "sources.va"
`include "passives.va"
`include "diode.va"

module Top ();
    electrical gnd, vin, a;
    vsrc #(.dc(0.0)) v1 (.p(vin), .n(gnd));
    res  #(.r(1.0)) r1  (.p(vin), .n(a));
    dio  #(.is(1.0e-14), .n_e(1.0), .rs(0.0)) d1 (.p(a), .n(gnd));
endmodule
