* urc lumped RC line equivalent, 5 segments — DC cross-check vs PHDL urc5.
* N=5 series R (100Ω each) + 5 shunt C (1n each, at every tap and output).
* V1=5V DC source, Rload=1k from vout to gnd. At DC, caps are open → the
* ladder is a pure resistive divider: Vout = 5 * 1000/(500+1000) = 3.3333V.
* Drops/segments matter: dropping one would give 5 * 1000/(400+1000) = 3.571V.
V1 vin 0 DC 5
Rs1 vin t1 100
Rs2 t1 t2 100
Rs3 t2 t3 100
Rs4 t3 t4 100
Rs5 t4 vout 100
Csh1 t1 0 1n
Csh2 t2 0 1n
Csh3 t3 0 1n
Csh4 t4 0 1n
Csh5 vout 0 1n
Rload vout 0 1k
.control
op
print v(vin) v(vout)
.endc
.end
