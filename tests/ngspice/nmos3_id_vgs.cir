* NMOS level 3 Id-Vgs sweep (golden): vds = 3 V fixed
* nsub (body-effect derivation) + nfs (subthreshold) active
* 26 points crossing cutoff -> subthreshold -> strong inversion
Vd d 0 DC 3
Vg g 0 DC 0
M1 d g 0 0 NMOD L=1u W=10u
.model NMOD NMOS (level=3 vto=1 kp=2e-5 nsub=1e15 nfs=1e11 theta=0.05
+ eta=0.1 kappa=0.5 xj=0.3u rd=100 rs=100)
.control
dc Vg 0 5 0.2
wrdata nmos3_id_vgs_sweep i(vd)
.endc
.end
