// noise_jfet_nlev3 — the same linear-region JFET as noise_jfet_nlev3.cir. With nlev=3 the channel
// noise source reads the model's analytic gm, which here is betap*vds*(2b+…)
// rather than the saturation form 2*beta*(vgs-vto).
`include "disciplines.vams"
`include "sources.va"
`include "passives.va"
`include "jfet.va"

module Top ();
    electrical gnd, vdd, g, d;
    vsrc #(.dc(5.0)) vd (.p(vdd), .n(gnd));
    vsrc #(.dc(0.0)) vg (.p(g),   .n(gnd));
    res  #(.r(5.0e3)) rd (.p(vdd), .n(d));
    jfet #(.vto(-2.0), .beta(1.0e-3), .lambda(0.0), .kf(0.0), .nlev(3.0)) j1 (.d(d), .g(g), .s(gnd));
endmodule
