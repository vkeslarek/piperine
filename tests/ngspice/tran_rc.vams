// tran_rc — the same RC charging circuit as tran_rc.cir. The DC operating
// point has v(out) = 1 V, so the transient only carries information because
// the run starts the cap discharged (ngspice `uic`; the piperine side passes
// ic out=0). The response is the analytic 1 - exp(-t/RC), which the target
// also anchors independently of ngspice.
`include "disciplines.vams"
`include "sources.va"
`include "passives.va"

module Top ();
    electrical gnd, vin, out;
    vsrc #(.dc(1.0)) v1 (.p(vin), .n(gnd));
    res  #(.r(1000.0)) r1 (.p(vin), .n(out));
    cap  #(.c(1.5915494309189535e-9)) c1 (.p(out), .n(gnd));
endmodule
