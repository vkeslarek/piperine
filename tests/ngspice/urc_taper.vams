// urc_taper — VAMS twin of urc_taper.cir: a tapered linear RC ladder built
// from the `urc_taper_5_k2` module. Per-segment R/C follow ngspice's K = 2
// geometric taper (`URCsetup`'s per-segment scaling), normalized to total
// R = 1 kΩ and total C = 10 nF — the same per-segment values the hand-built
// `.cir` writes down explicitly. The AC response must match ngspice per
// frequency (NGP-01) where a uniform ladder (K = 1) does not.
`include "disciplines.vams"
`include "passives.va"
`include "sources.va"
`include "urc.va"

module Top ();
    electrical gnd, in, out;
    vsrc #(.dc(0.0), .ac_mag(1.0)) v1 (.p(in), .n(gnd));
    urc_taper_5_k2 u1 (.p(in), .n(out), .g(gnd));
endmodule
