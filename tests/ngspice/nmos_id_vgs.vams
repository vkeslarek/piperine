// NMOS Id-Vgs sweep — same circuit as nmos_id_vgs.cir; the harness stages
// vg.dc per sweep point and reads the drain-supply branch current i(d,gnd).
`include "disciplines.vams"
`include "sources.va"
`include "mos.va"

module Top ();
    electrical gnd, d, g, b;
    vsrc #(.dc(2.0))  vd (.p(d), .n(gnd));
    vsrc #(.dc(0.0))  vg (.p(g), .n(gnd));
    vsrc #(.dc(-1.0)) vb (.p(b), .n(gnd));
    mos1 #(.l(2.0e-6), .w(10.0e-6), .vto(1.0), .kp(2.0e-5), .lambda(0.02), .gamma(0.5), .phi(0.65))
        m1 (.d(d), .g(g), .s(gnd), .b(b));
endmodule
