`include "disciplines.vams"
`include "sources.va"
`include "passives.va"
`include "diode.va"

module Top ();
    electrical gnd, vin, a, b;
    vsrc #(.dc(5.0)) v1 (.p(vin), .n(gnd));
    res  #(.r(1.0e3)) r1 (.p(vin), .n(a));
    dio  #(.is(1.0e-14), .n_e(1.0), .rs(0.0)) d1 (.p(a), .n(b));
    dio  #(.is(1.0e-14), .n_e(1.0), .rs(0.0)) d2 (.p(b), .n(gnd));
endmodule
