// noise_mos_tox1e7 — the twin of noise_mos_cox0 with tox stated explicitly, at
// the 1e-7 the flicker source assumes when Cox is zero. The two must produce
// the same spectrum; that equality is the substitution NGP-12 asks for.
`include "disciplines.vams"
`include "sources.va"
`include "passives.va"
`include "mos.va"

module Top ();
    electrical gnd, vdd, g, d;
    vsrc #(.dc(5.0)) vd (.p(vdd), .n(gnd));
    vsrc #(.dc(3.0)) vg (.p(g),   .n(gnd));
    res  #(.r(6.2e3)) rd (.p(vdd), .n(d));
    mos1 #(.l(1.0e-6), .w(100.0e-6), .vto(1.0), .kp(2.0e-5), .lambda(0.0),
           .kf(1.0e-26), .af(1.0), .tox(1.0e-7))
        m1 (.d(d), .g(g), .s(gnd), .b(gnd));
endmodule
