// uic_mos — VAMS twin of uic_mos.cir (NGP-10 part 2). The mos1's
// `.ic_vds(2.0), .ic_vgs(5.0)` writes the same `IC=2.0,5.0` line
// ngspice's `.tran … uic` reads.
//
// KNOWN GAP (T44, carried from T42): `headers/spice/mos.va`'s mos1 no
// longer wires `ic_vds`/`ic_vgs` into an `@ initial` seed — the real
// Verilog-A `<+` contribution operator cannot coexist with the module's
// own unconditional Flow contributions on the same branches the way
// PHDL's `<-` (Force, a non-contribution primitive) could (mos.va's own
// file-header comment, T42). `ic_vds`/`ic_vgs` stay declared, unused
// parameters. This fixture is kept, migrated faithfully, so the gap is
// measured rather than hidden — see the T44 progress-log entry.
`include "disciplines.vams"
`include "sources.va"
`include "passives.va"
`include "mos.va"

module Top ();
    electrical gnd, in, out;
    vsrc #(.dc(5.0)) vin (.p(in), .n(gnd));
    cap  #(.c(1.0e-7), .ic(2.0)) c1 (.p(out), .n(gnd));
    mos1 #(.l(2.0e-6), .w(10.0e-6), .ic_vds(2.0), .ic_vgs(5.0),
           .vto(1.0), .kp(2.0e-5), .lambda(0.02), .gamma(0.5), .phi(0.65))
        m1 (.d(out), .g(in), .s(gnd), .b(gnd));
endmodule
