// NMOS level 2 diode-connected load — same circuit as nmos2_load.cir.
`include "disciplines.vams"
`include "sources.va"
`include "passives.va"
`include "mos.va"

module Top ();
    electrical gnd, vdd, d;
    vsrc #(.dc(5.0)) vd (.p(vdd), .n(gnd));
    res  #(.r(10.0e3)) r1 (.p(vdd), .n(d));
    mos2 #(.l(2.0e-6), .w(10.0e-6), .vto(1.0), .kp(2.0e-5), .lambda(0.0))
        m1 (.d(d), .g(d), .s(gnd), .b(gnd));
endmodule
