// disto_diode — same circuit as disto_diode.cir; the harness runs
// run_disto(f1=1e6, amplitude=1.0) so the input tone is ac_mag × 1.0 = 0.05
// (ngspice's distof1), and compares HD2/HD3 against ngspice's harmonic
// components normalized by its AC fundamental.
`include "disciplines.vams"
`include "sources.va"
`include "passives.va"
`include "diode.va"

module Top ();
    electrical gnd, in, out;
    vsrc #(.dc(0.3), .ac_mag(0.05)) v1 (.p(in), .n(gnd));
    res  #(.r(1000.0)) r1 (.p(in), .n(out));
    dio  #(.is(1.0e-14), .n_e(1.0), .rs(0.0)) d1 (.p(out), .n(gnd));
endmodule
