// NMOS level 3 Id-Vgs sweep — same circuit as nmos3_id_vgs.cir; the
// harness stages vg.dc per sweep point and reads vd's branch current.
`include "disciplines.vams"
`include "sources.va"
`include "mos.va"

module Top ();
    electrical gnd, d, g;
    vsrc #(.dc(3.0)) vd (.p(d), .n(gnd));
    vsrc #(.dc(0.0)) vg (.p(g), .n(gnd));
    mos3 #(.l(1.0e-6), .w(10.0e-6), .vto(1.0), .kp(2.0e-5), .nsub(1.0e15), .nfs(1.0e11),
           .theta(0.05), .eta(0.1), .kappa(0.5),
           .xj(0.3e-6), .rd(100.0), .rs(100.0))
        m1 (.d(d), .g(g), .s(gnd), .b(gnd));
endmodule
