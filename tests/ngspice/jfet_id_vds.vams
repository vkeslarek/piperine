// N-JFET Id-Vds sweep — same circuit as jfet_id_vds.cir; the harness stages
// vd.dc per sweep point and reads that source's own branch current.
`include "disciplines.vams"
`include "sources.va"
`include "jfet.va"

module Top ();
    electrical gnd, d, g;
    vsrc #(.dc(0.0))  vd (.p(d), .n(gnd));
    vsrc #(.dc(-0.5)) vg (.p(g), .n(gnd));
    jfet #(.vto(-2.0), .beta(1.0e-3), .lambda(0.02), .rd(100.0), .rs(100.0)) j1 (.d(d), .g(g), .s(gnd));
endmodule
