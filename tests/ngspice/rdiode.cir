* R-diode clamp
V1 vin 0 DC 5
R1 vin out 1k
D1 out 0 DMOD
.model DMOD D (is=1e-14 n=1 rs=0)
.control
op
print v(out) v(vin)
.endc
.end
