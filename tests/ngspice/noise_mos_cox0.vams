// noise_mos_cox0 — the same tox-less level-1 card as noise_mos_cox0.cir. With
// no tox the model's Cox is 0, and the flicker density substitutes ngspice's
// assumed tox = 1e-7 rather than dividing by zero or dropping the source.
`include "disciplines.vams"
`include "sources.va"
`include "passives.va"
`include "mos.va"

module Top ();
    electrical gnd, vdd, g, d;
    vsrc #(.dc(5.0)) vd (.p(vdd), .n(gnd));
    vsrc #(.dc(3.0)) vg (.p(g),   .n(gnd));
    res  #(.r(6.2e3)) rd (.p(vdd), .n(d));
    mos1 #(.l(1.0e-6), .w(100.0e-6), .vto(1.0), .kp(2.0e-5), .lambda(0.0),
           .kf(1.0e-26), .af(1.0))
        m1 (.d(d), .g(g), .s(gnd), .b(gnd));
endmodule
