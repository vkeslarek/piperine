`include "disciplines.vams"
`include "sources.va"
`include "passives.va"
`include "diode.va"

module Top ();
    electrical gnd, vin, out;
    vsrc #(.dc(5.0)) v1 (.p(vin), .n(gnd));
    res  #(.r(1.0e3)) r1 (.p(vin), .n(out));
    dio  #(.is(1.0e-14), .n_e(1.0), .rs(0.0)) d1 (.p(out), .n(gnd));
endmodule
