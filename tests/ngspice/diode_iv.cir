* diode I-V sweep (golden): forward + reverse through 1 ohm series
V1 vin 0 DC 0
R1 vin a 1
D1 a 0 DMOD
.model DMOD D (is=1e-14 n=1 rs=0)
.control
dc V1 -1 0.8 0.05
wrdata diode_iv_sweep i(v1)
.endc
.end
