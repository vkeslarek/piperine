// noise_switch_off — the same open-switch network as noise_switch_off.cir.
`include "disciplines.vams"
`include "sources.va"
`include "passives.va"
`include "switches.va"

module Top ();
    electrical gnd, in, c, a;
    vsrc #(.dc(1.0), .ac_mag(1.0)) vin (.p(in), .n(gnd));
    vsrc #(.dc(0.0)) vc (.p(c), .n(gnd));
    res  #(.r(1.0e3)) r1 (.p(in), .n(a));
    sw   #(.off(1), .vt(1.0), .ron(1.0), .roff(10.0e3)) s1 (.p(a), .n(gnd), .cp(c), .cn(gnd));
endmodule
