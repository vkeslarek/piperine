* uic_mos — UIC cross-check for mos1's IC=VDS,VGS (NGP-10 part 2).
* The drain cap pre-charges to 2 V via the mos1's IC=2.0,5.0; the gate
* stays at 5 V (Vin forces this, consistent with IC_vgs=5). The mos is
* strongly on (vgs-vto = 4 V overdrive) and discharges the cap from its
* 2 V IC toward ground through its channel — a real transient both
* ngspice and piperine integrate, and a discriminating check that fails
* when the IC is dropped (drain starts at 0 V from the DC OP) or when a
* default-ic clamp misfires (drain pinned to 0 V for the whole run). The
* .model is Shichman-Hodges level=1, identical to the PHDL twin's
* Mos1Model. `.options interp` makes ngspice interpolate its adaptive
* steps onto the print grid before recording.
Vin in 0 DC 5
C1 out 0 100n IC=2.0
M1  out in 0 0 NMOD L=2u W=10u IC=2.0,5.0
.model NMOD NMOS (level=1 vto=1 kp=2e-5 lambda=0.02 gamma=0.5 phi=0.65)
.options interp
.control
tran 0.05u 5u uic
wrdata uic_mos_tran v(out)
.endc
.end
