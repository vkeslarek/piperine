// urc_fmax — VAMS twin of urc_fmax.cir (NGP-19). ngspice's `URCsetup`
// derives the lump count from `FMAX` when `N` is not given
// (`urcsetup.c:84-89`): with `K = 1.5`, `r0 = L·RPERL`, `c0 = L·CPERL`,
// `wnorm = FMAX · r0 · c0 · 2π`. At ngspice's defaults (FMAX = 1e9,
// L = 1, RPERL = 1000, CPERL = 1e-12, K = 1.5) `wnorm ≈ 6.28 < 35`, so
// `N = 3`. The piperine side lands on the same 3-segment ladder by
// instantiating `urc` with its own declared default (`segs = URC_DEFAULT_N
// = 3`, `urc.va`) — the same constant `urc.phdl` used to derive from the
// same formula and the same defaults.
//
// The cross-check is the same hand-built discrete R/C ladder as
// `urc_lump{2,5,10}` — three series 100 Ω resistors, three shunt 1 nF
// capacitors, 1 kΩ load. At DC, Vout = 5·1000/(300+1000) = 3.846 V.
`include "disciplines.vams"
`include "passives.va"
`include "sources.va"
`include "urc.va"

module Top ();
    electrical gnd, vin, vout;
    vsrc #(.dc(5.0)) v1 (.p(vin), .n(gnd));
    urc  #(.r(100.0), .c(1.0e-9)) u1 (.p(vin), .n(vout), .g(gnd));
    res  #(.r(1.0e3)) rl (.p(vout), .n(gnd));
endmodule
