// temp_diode — the same forward-biased diode as temp_diode.cir. The piperine
// side runs one operating point per temperature with
// SolverConfig.temperature set to the ngspice .temp value (Celsius + 273.15).
`include "disciplines.vams"
`include "sources.va"
`include "passives.va"
`include "diode.va"

module Top ();
    electrical gnd, vin, out;
    vsrc #(.dc(1.0)) v1 (.p(vin), .n(gnd));
    res  #(.r(100.0)) r1 (.p(vin), .n(out));
    dio  #(.is(1.0e-14), .n_e(1.0), .rs(0.0)) d1 (.p(out), .n(gnd));
endmodule
