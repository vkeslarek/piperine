// NGSPICE faithful models — uniform distributed RC (URC) lumped line.
//
// Source: ngspice/src/spicelib/devices/urc/  (URC device, lumped RC model).
//
// The ngspice URC device approximates a uniform distributed RC line by a
// finite ladder of N series resistors and N shunt capacitors, one C at every
// tap node including the output. The total line resistance is RPERL·L and
// the total line capacitance is CPERL·L; each lump takes a share whose size
// follows ngspice's geometric taper (the `K` parameter, NGP-16).
//
// Geometric taper (NGP-16). ngspice's `URCsetup` (`urcsetup.c:80-92`) scales
// each segment by `K^i`: segment `i` (0-indexed from the input end) takes a
// `K^i` share of the line total. With `K = 1` the geometric sum collapses to
// `N` and every segment gets an equal `1/N` share (the uniform ladder); with
// `K > 1` the share grows geometrically toward the output.
//
// Migrated from `urc.phdl` (T43, VAMS-08) — the `urc[N]`/`urc_taper_5_k2`/
// `urc_isperl_5_k2` behavior (K-taper, ISPERL diode-mode shunt path)
// preserved exactly; only the authoring form changes:
//
//   1. `urc` is the generic, single-authoring ladder (PHDL precedent:
//      `urc[N]`), using `genvar`/`generate for` over `segs` `urc_seg`
//      lumps. PHDL's own array-wire structural-connection idiom
//      (`wire tap : Electrical[N+1]; tap[0] = p; tap[N] = n;`) has no VAMS
//      equivalent — VAMS's `<net_lvalue> = <net_lvalue>` node-alias
//      statement doesn't exist (LRM Annex A has no such production; only
//      `<+` contribution and blocking/non-blocking assignment to
//      variables, neither of which aliases two distinct nets). The real
//      Verilog-A idiom used instead: only the *strictly internal* taps
//      (`tap[0:segs-2]`) get a declared array net; the first and last
//      segments are authored directly against the module's own `p`/`n`
//      ports (`s0`/`slast`, outside the generated loop), and the loop
//      covers only the interior segments. This requires `segs >= 2`
//      (SPEC_DEVIATION, enforced on `urc`'s own declared default by the
//      `from [2:1000]` range below, C6/E-STD — this file could never be
//      edited to declare a `segs` default below 2 without an E4006 range
//      violation at `urc`'s own elaboration). The range check does NOT
//      fire on a caller's instance override (`urc #(.segs(1)) u1 (...)`
//      elaborates without error) — see the "PRE-EXISTING GAP" note below:
//      an instance override never reaches the generate loop bound at all,
//      so a too-small override is silently inert, not silently wrong.
//      Every golden fixture this model is cross-checked against
//      (`urc_lump2/5/10`, `urc_fmax`'s `URC_DEFAULT_N = 3`) already uses
//      `segs >= 2` as a *declared default* (see the gap note), so this is
//      a real but inert scope boundary, not a behavior change to the
//      covered cases.
//   2. `urc_taper_5_k2` and `urc_isperl_5_k2` are unchanged in shape from
//      the PHDL predecessor (direct `res`/`cap`/`dio` leaves, values baked
//      at module-lowering time) — only `pow(k, i)` now resolves through
//      the elaboration-constant evaluator's built-in-math-function support
//      (the second T43 blocker; `elab::const_eval::ConstEnv::eval_call`)
//      instead of PHDL's own const evaluator.
//
// PRE-EXISTING GAP carried forward, now visible on `segs` too (not new,
// not introduced by this migration — `elab/lower/generate.rs`'s
// `UnrollGenerate` unrolls a module's generate body exactly once per
// module *declaration*, using that module's own declared param DEFAULTS,
// before any instance ever overrides anything; PHDL's `urc.phdl` already
// documented this for `k` — "a per-instance `k` override... does not
// reach the leaves via the param chain"). Since `segs` now also drives
// the loop bound, `urc #(.segs(5)) u1 (...)` still elaborates and
// JIT-compiles, but the generated ladder has `urc`'s own DECLARED
// default segment count (`URC_DEFAULT_N = 3`), not 5 — the override
// reaches every `urc_seg` LEAF param (`r`/`c`/`k` do reach `res`/`cap`
// through the ordinary per-instance override path, since those are not
// generate-loop-bound quantities) but never the loop's own iteration
// count. PHDL's `urc[N]` sidestepped this because `[N]` was a
// compile-time module-name parameter (monomorphizing a distinct
// `urc__5`/`urc__10` module declaration per `N`, each with its own
// generate-unrolled body) — VAMS has no equivalent module-name
// parameterization. Getting a non-default segment count in VAMS today
// means declaring another module whose own `parameter integer segs`
// default is the wanted count (the `urc_lump2/5/10` golden fixtures,
// still `.phdl`/unmigrated until T44, will need exactly that treatment
// when they migrate — flagged here so it isn't rediscovered from
// scratch). Fixing the underlying "generate unrolls against declared
// defaults, not instance overrides" limitation is a flatten/codegen
// feature of its own, out of this migration task's scope.
//
// Per-segment R/C are exposed as params so a host can scale them via the
// flat-label override contract (`u1.s[1].r1`, `u1.s[1].c1`, …) — same
// contract as before, only the generated label shape changes with the
// authoring form (see `s0`/`slast`/`s[i]` below).
//
// NGP-19: FMAX → N auto-selection. ngspice derives the lump count from
//   `FMAX` when `N` is not given (`urcsetup.c:84-89`): with `p = K`,
//   `r0 = L·RPERL`, `c0 = L·CPERL`,
//       wnorm = FMAX · r0 · c0 · 2π
//       N = max(3, floor( log(wnorm · ((p−1)/p)²) / log(p) ))
//   with the special case `wnorm < 35 ⇒ N = 3`. `URC_DEFAULT_N` below is
//   the value ngspice's default deck picks when given no `N=` (FMAX = 1
//   GHz, L = 1 m, RPERL = 1 kΩ/m, CPERL = 1 pF/m, K = 1.5 ⇒ wnorm ≈ 6.28,
//   well under the 35 cutoff ⇒ N = 3) — a host with different defaults
//   instantiates `urc` with an explicit `segs` directly; explicit `segs`
//   always wins over the FMAX formula, same precedence PHDL's comment
//   already documented.
// ════════════════════════════════════════════════════════════════════════════

`include "disciplines.vams"
`include "constants.va"
`include "passives.va"
`include "diode.va"

// wnorm = FMAX · L · RPERL · L · CPERL · 2π
//       = 1e9 · 1 · 1000 · 1 · 1e-12 · 2π
//       = 2π ≈ 6.283185307179586  (well below the 35 cutoff → N = 3)
`define URC_DEFAULT_FMAX  1.0e9
`define URC_DEFAULT_L     1.0
`define URC_DEFAULT_RPERL 1000.0
`define URC_DEFAULT_CPERL 1.0e-12
`define URC_DEFAULT_K     1.5
`define URC_DEFAULT_WNORM 6.283185307179586
`define URC_DEFAULT_N     3

// ════════════════════════════════════════════════════════════════════════════
//  urc_seg — one ladder lump: a series R (p->n) and a shunt C (n->g).
//
//  Pure-structural: instantiates `res` and `cap` and owns no analog body.
//  This is the recursion base for flattening — a mid-level module whose
//  sub-instances are leaves. When inlined into a parent, its two leaves
//  reappear under path-prefixed labels (e.g. `s0.r1`, `s0.c1`).
// ════════════════════════════════════════════════════════════════════════════

module urc_seg (inout electrical p, inout electrical n, inout electrical g);
    parameter real r = 100.0;    // series resistance of this lump (Ohm)
    parameter real c = 1.0e-9;   // shunt capacitance of this lump (F)

    res #(.r(r)) r1 (p, n);
    cap #(.c(c)) c1 (n, g);
endmodule

// ════════════════════════════════════════════════════════════════════════════
//  urc — generic lumped RC line of `segs` `urc_seg` lumps (NGP-18, NGP-22).
//
//  See the file header for why the first/last segments (`s0`/`slast`) are
//  authored directly against the module's own ports and only the interior
//  segments (`segs >= 3`) go through the `generate for` loop over the
//  internal `tap[0:segs-2]` array — `segs == 2` degenerates to just
//  `s0`/`slast` with zero loop iterations, still a correct 2-segment
//  ladder.
//
//  Geometric taper (NGP-16). Each segment `i` receives `r·k^i` and `c·k^i`
//  via the per-segment `pow(k, i)` factor. `k = 1.0` (the default) makes
//  `pow` a no-op and the ladder stays uniform — the contract the golden
//  `urc_lump2/5/10` DC fixtures baseline.
// ════════════════════════════════════════════════════════════════════════════

module urc (inout electrical p, inout electrical n, inout electrical g);
    parameter integer segs = `URC_DEFAULT_N from [2:1000];
    parameter real r = 100.0;
    parameter real c = 1.0e-9;
    parameter real k = 1.0;

    // 0-indexed: array indices are always 0..width-1 regardless of the
    // declared `[msb:lsb]` literal (the POM's `NetType::Array` tracks only
    // a width, not an offset) — `tap[0:segs-2]` is `segs-1` internal nodes,
    // `tap[i-1]` is the node just before segment `i`'s output.
    electrical tap[0:segs-2];

    urc_seg #(.r(r), .c(c)) s0 (p, tap[0], g);

    genvar i;
    generate
        for (i = 1; i < segs - 1; i = i + 1) begin: s
            urc_seg #(.r(r * pow(k, i)), .c(c * pow(k, i))) u (tap[i - 1], tap[i], g);
        end
    endgenerate

    urc_seg #(.r(r * pow(k, segs - 1)), .c(c * pow(k, segs - 1))) slast (tap[segs - 2], n, g);
endmodule

// ════════════════════════════════════════════════════════════════════════════
//  urc2 / urc5 / urc10 — fixed-segment-count ladders (T44, `tests/ngspice/
//  urc_lump{2,5,10}.vams`).
//
//  `urc`'s own `segs` OVERRIDE never reaches its `generate for` loop bound
//  (the PRE-EXISTING GAP documented above: `UnrollGenerate` unrolls a
//  module's generate body once per module *declaration*, against that
//  module's own declared `segs` DEFAULT, before any instance-level
//  override is applied). The file header already names the fix for a
//  caller that needs a non-default segment count: "declaring another
//  module whose own `segs` default is the wanted count." These three are
//  exactly that — same body as `urc`, only the declared default differs —
//  so `urc_lump2/5/10`'s golden fixtures get the fixed 2/5/10-segment
//  ladder their `.cir` twins hand-build explicitly, without depending on
//  the override path this module doesn't have.
// ════════════════════════════════════════════════════════════════════════════

module urc2 (inout electrical p, inout electrical n, inout electrical g);
    parameter integer segs = 2 from [2:1000];
    parameter real r = 100.0;
    parameter real c = 1.0e-9;
    parameter real k = 1.0;

    electrical tap[0:segs-2];

    urc_seg #(.r(r), .c(c)) s0 (p, tap[0], g);

    genvar i;
    generate
        for (i = 1; i < segs - 1; i = i + 1) begin: s
            urc_seg #(.r(r * pow(k, i)), .c(c * pow(k, i))) u (tap[i - 1], tap[i], g);
        end
    endgenerate

    urc_seg #(.r(r * pow(k, segs - 1)), .c(c * pow(k, segs - 1))) slast (tap[segs - 2], n, g);
endmodule

module urc5 (inout electrical p, inout electrical n, inout electrical g);
    parameter integer segs = 5 from [2:1000];
    parameter real r = 100.0;
    parameter real c = 1.0e-9;
    parameter real k = 1.0;

    electrical tap[0:segs-2];

    urc_seg #(.r(r), .c(c)) s0 (p, tap[0], g);

    genvar i;
    generate
        for (i = 1; i < segs - 1; i = i + 1) begin: s
            urc_seg #(.r(r * pow(k, i)), .c(c * pow(k, i))) u (tap[i - 1], tap[i], g);
        end
    endgenerate

    urc_seg #(.r(r * pow(k, segs - 1)), .c(c * pow(k, segs - 1))) slast (tap[segs - 2], n, g);
endmodule

module urc10 (inout electrical p, inout electrical n, inout electrical g);
    parameter integer segs = 10 from [2:1000];
    parameter real r = 100.0;
    parameter real c = 1.0e-9;
    parameter real k = 1.0;

    electrical tap[0:segs-2];

    urc_seg #(.r(r), .c(c)) s0 (p, tap[0], g);

    genvar i;
    generate
        for (i = 1; i < segs - 1; i = i + 1) begin: s
            urc_seg #(.r(r * pow(k, i)), .c(c * pow(k, i))) u (tap[i - 1], tap[i], g);
        end
    endgenerate

    urc_seg #(.r(r * pow(k, segs - 1)), .c(c * pow(k, segs - 1))) slast (tap[segs - 2], n, g);
endmodule

// ════════════════════════════════════════════════════════════════════════════
//  urc_taper_5_k2 — five-segment tapered URC ladder (NGP-16, K = 2).
//
//  The taper is ngspice's `K = 2` geometric progression (`urcsetup.c:80-92`)
//  on a *linear* ladder of N series R + N shunt C, normalized to keep
//  total R = 1 kOhm and total C = 10 nF:
//      r_i = Rtotal · K^i / Sigma K^j = 1000 · 2^i / 31
//      c_i = Ctotal · K^i / Sigma K^j = 1e-8 · 2^i / 31
//  The two ladder topologies differ: ngspice's URC is symmetric (2N R,
//  2N-1 C, half of `Rtotal` on each side); piperine's `urc_taper_5_k2`
//  is linear (N R, N C, all of `Rtotal` on one side). The geometric taper
//  per segment is the same; only the normalization differs. The values are
//  baked at module-lowering time so the taper is real at both DC and AC.
//
//  This module is the piperine twin of `tests/ngspice/urc_taper.cir`, which
//  writes the same per-segment ladder out by hand. The AC cross-check
//  fails when the taper is reverted (a uniform ladder at the same total R/C
//  gives a measurably different transfer function — the test falsifies it).
//
//  Authored as direct `res`/`cap` leaves rather than as a `urc_seg` chain
//  because the flatten pass bakes per-segment values at module-lowering
//  time using param defaults, so a `k` override on a parent `urc`
//  `#(.k(2.0))` does not reach the leaves. Direct leaves make the taper
//  observable from the flat netlist without runtime staging.
// ════════════════════════════════════════════════════════════════════════════

module urc_taper_5_k2 (inout electrical p, inout electrical n, inout electrical g);
    electrical t1;
    electrical t2;
    electrical t3;
    electrical t4;

    // r_i = 1000 * 2^i / 31 (Ohm)  for i = 0..4
    res #(.r(1000.0 * pow(2.0, 0.0) / 31.0)) r1 (p,  t1);
    res #(.r(1000.0 * pow(2.0, 1.0) / 31.0)) r2 (t1, t2);
    res #(.r(1000.0 * pow(2.0, 2.0) / 31.0)) r3 (t2, t3);
    res #(.r(1000.0 * pow(2.0, 3.0) / 31.0)) r4 (t3, t4);
    res #(.r(1000.0 * pow(2.0, 4.0) / 31.0)) r5 (t4, n);

    // c_i = 1e-8 * 2^i / 31 (F)  for i = 0..4
    cap #(.c(1.0e-8 * pow(2.0, 0.0) / 31.0)) c1 (t1, g);
    cap #(.c(1.0e-8 * pow(2.0, 1.0) / 31.0)) c2 (t2, g);
    cap #(.c(1.0e-8 * pow(2.0, 2.0) / 31.0)) c3 (t3, g);
    cap #(.c(1.0e-8 * pow(2.0, 3.0) / 31.0)) c4 (t4, g);
    cap #(.c(1.0e-8 * pow(2.0, 4.0) / 31.0)) c5 (n,  g);
endmodule

// ════════════════════════════════════════════════════════════════════════════
//  urc_isperl_5_k2 — five-segment tapered URC ladder with ISPERL diode-mode
//  shunt path (NGP-17, K = 2).
//
//  When ngspice's URC model is given `ISPERL > 0`, the per-segment shunt
//  branch becomes a diode whose `cjo` carries the per-segment capacitance
//  and whose `is` carries the per-segment saturation current
//  (`urcsetup.c:97-113, 179-216`). This module is the linear-ladder analogue:
//  same K = 2 taper as `urc_taper_5_k2`, but each shunt is a `dio` instance
//  whose model parameters are the per-segment unit (`cjo = c_unit`,
//  `is = i_unit`) and whose `area = K^i` scales the unit by the geometric
//  factor (mirroring ngspice's per-instance `area = prop`). The diode
//  replaces the capacitor — at DC the shunt conducts (the diode's
//  exponential I-V); at AC it presents both conductance and junction cap.
//
//  Parameters chosen for a measurable but stable DC operating point:
//      c_unit  = 1e-8 / 31   (matches urc_taper_5_k2's per-segment cap)
//      i_unit  = 1e-12 / 31  (per-segment saturation current at area = 1)
//  With `Vsource = 5 V`, `Rload = 1 kOhm` the diodes clamp the tap nodes
//  well below the capacitive case's voltage — a discriminating test that
//  fails if the diode shunt is missing or replaced by a cap.
//
//  Like `urc_taper_5_k2`, authored as direct `res`/`dio` leaves so the
//  taper values bake at module-lowering time and reach the flat netlist
//  without runtime staging.
// ════════════════════════════════════════════════════════════════════════════

module urc_isperl_5_k2 (inout electrical p, inout electrical n, inout electrical g);
    electrical t1;
    electrical t2;
    electrical t3;
    electrical t4;

    // r_i = 1000 * 2^i / 31 (Ohm) — same taper as urc_taper_5_k2.
    res #(.r(1000.0 * pow(2.0, 0.0) / 31.0)) r1 (p,  t1);
    res #(.r(1000.0 * pow(2.0, 1.0) / 31.0)) r2 (t1, t2);
    res #(.r(1000.0 * pow(2.0, 2.0) / 31.0)) r3 (t2, t3);
    res #(.r(1000.0 * pow(2.0, 3.0) / 31.0)) r4 (t3, t4);
    res #(.r(1000.0 * pow(2.0, 4.0) / 31.0)) r5 (t4, n);

    // d_i : dio with cjo=c_unit, is=i_unit, area=K^i (per-segment scaling).
    // c_unit = 1e-8/31; i_unit = 1e-12/31. `n_e`/`rs` are dio's own
    // emission-coefficient/series-resistance params (n_e = 1.0, rs = 0.0
    // matches PHDL's `DioModel { .n = 1.0, .rs = 0.0 }`, T42's naming note:
    // `n_e` because `n` is the port).
    dio #(.cjo(1.0e-8 / 31.0), .is(1.0e-12 / 31.0), .n_e(1.0), .rs(0.0), .area(pow(2.0, 0.0))) d1 (t1, g);
    dio #(.cjo(1.0e-8 / 31.0), .is(1.0e-12 / 31.0), .n_e(1.0), .rs(0.0), .area(pow(2.0, 1.0))) d2 (t2, g);
    dio #(.cjo(1.0e-8 / 31.0), .is(1.0e-12 / 31.0), .n_e(1.0), .rs(0.0), .area(pow(2.0, 2.0))) d3 (t3, g);
    dio #(.cjo(1.0e-8 / 31.0), .is(1.0e-12 / 31.0), .n_e(1.0), .rs(0.0), .area(pow(2.0, 3.0))) d4 (t4, g);
    dio #(.cjo(1.0e-8 / 31.0), .is(1.0e-12 / 31.0), .n_e(1.0), .rs(0.0), .area(pow(2.0, 4.0))) d5 (n,  g);
endmodule
