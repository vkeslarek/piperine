// NGSPICE faithful models — passive devices.
//
// Source: ngspice/src/spicelib/devices/{res,cap,ind}/
//   restemp.c  resload.c  resparam.c  resmpar.c  resdefs.h
//   captemp.c  capload.c  capsetup.c  capparam.c  capmpar.c  capdefs.h
//   indtemp.c  indload.c  indsetup.c  indparam.c  indmpar.c  inddefs.h
//   muttemp.c  mutparam.c  (mutual inductance, lives in ind/)
//
// All equations are translated line-by-line from the C source, same as the
// PHDL predecessor this file replaces (T41, VAMS-08 — a dialect rewrite,
// not a re-derivation).
//
// ngspice's `XXXGiven` flags mapped onto PHDL optionals (`T?`/`.is_present()`/
// `.get_or(default)`); Verilog-A has neither optional types nor
// `$param_given()` wired in this codegen yet (LRM §9.19 exists but is
// unimplemented — Phase 9/T47 scope, general system tasks). The mechanical
// equivalent used throughout this file: a negative-sentinel default
// (`parameter real x = -1.0;`) for any quantity that is never legitimately
// negative (resistance, capacitance, width, temperature, ...) — `x >= 0.0`
// stands in for "was given", identical decision logic, zero numeric change.
// PHDL's separate `model`-bundle field and instance-param field that shared
// one physical meaning (e.g. `model.tc1` vs instance `tc1`, both "the
// resistor's first temperature coefficient") collapse into ONE flat VAMS
// `parameter` — Verilog-A modules have no model/instance two-tier parameter
// system; a real device's own instantiation-time parameter override
// already gives the same "explicit value wins over the compiled-in default"
// precedence PHDL's cascade computed by hand. Where the collapse is not a
// pure rename (e.g. `res`'s `r` derivation, which chooses between an
// explicit value, a geometry-derived value, and a final fallback), the
// original three-way branch is preserved verbatim, just keyed off the
// merged parameter's sentinel.
//
// PHDL's `dest <- src` (`BindOp::Force`) has no VAMS production (T32's
// documented SPEC_DEVIATION, `.specs/features/verilog-ams-support/tasks.md`)
// — real Verilog-A has only `<+`. Every unconditional `<-` below becomes
// `<+` (semantically identical per T32's note: Force was never
// conditional-contribution-specific). `cap`'s UIC seed
// (`@ initial { V(p,n) <- ic; }`) is the one exception: converting it to the
// real Verilog-A idiom (`@(initial_step) V(p,n) <+ ic;`) does not merely
// change syntax — it puts a Potential contribution on a branch that already
// carries an unconditional Flow contribution (`I(p,n) <+ m*ddt(...)`), which
// the elaborator rejects as LRM §5.4.2's potential+flow conflict regardless
// of the `@(initial_step)` guard (confirmed by direct test — the current
// pipeline has no lowering path for a Contribution inside an event body at
// all, per T32's note). Emitting it would make every circuit using `cap`
// fail to elaborate, not just IC-specific cases, so the IC contribution is
// left un-migrated (dropped) rather than shipped broken; see the comment at
// its former call site. This is the same gap NGP-10 already documents for
// `ind`'s current-seed IC (`ROADMAP.md`, `ngspice-parity` spec) — a codegen
// limitation, not something this dialect-translation task can or should
// paper over.

`include "disciplines.vams"
`include "constants.va"

// ════════════════════════════════════════════════════════════════════════════
//  RESISTOR  (ngspice `R` element, res device)
//  Source: restemp.c, resload.c
// ════════════════════════════════════════════════════════════════════════════

module res (inout electrical p, inout electrical n);
    // ── Model-card parameters (formerly `ResModel`) ──────────────────────────
    parameter real rsh       = 0.0;       // sheet resistance (Ohm/sq)
    parameter real defWidth  = 10.0e-6;   // default width (m)
    parameter real defLength = 10.0e-6;   // default length (m)
    parameter real narrow    = 0.0;       // width reduction (m)
    parameter real short     = 0.0;       // length reduction (m)
    parameter real kf        = 0.0;       // flicker noise coefficient
    parameter real af        = 1.0;       // flicker noise exponent
    parameter real bv_max    = -1.0;      // max voltage (SOA); < 0 = no limit (unused downstream, kept for API fidelity)

    // ── Instance parameters — `r`/`tc1`/`tc2` merged with their model-card
    //    namesakes (see file header); `w`/`l`/`temp`/`ac` keep PHDL's
    //    negative-sentinel "not given" convention. ──────────────────────────
    parameter real r      = -1.0;    // resistance (Ohm) override; < 0 = derive from geometry
    parameter real w      = -1.0;    // width (m); < 0 = defWidth
    parameter real l      = -1.0;    // length (m); < 0 = defLength
    parameter real temp   = -1.0;    // absolute temp (K); < 0 = ambient+dtemp
    parameter real dtemp  = 0.0;     // delta temp from ambient (K)
    parameter real scale  = 1.0;     // scale factor
    parameter real m      = 1.0;     // parallel multiplier
    parameter real tc1    = 0.0;     // 1st temp coefficient (1/K)
    parameter real tc2    = 0.0;     // 2nd temp coefficient (1/K^2)
    parameter real ac     = -1.0;    // AC resistance (Ohm); < 0 = use g_dc
    parameter integer noisy = 1;     // generate noise?

    real t, w_eff, l_eff, r_nom, diff, factor, g_dc, g_ac, g_now, i_r;

    analog begin
        // ── Temperature (restemp.c:50-57) — temp given => dtemp ignored ─────
        t = (temp >= 0.0) ? temp : ($temperature() + dtemp);

        // ── Width / length defaults (restemp.c:59-61) ────────────────────────
        w_eff = (w >= 0.0) ? w : defWidth;
        l_eff = (l >= 0.0) ? l : defLength;

        // ── Resistance derivation (restemp.c:64-77) ──────────────────────────
        // Explicit r wins; then geometry (rsh); else 1 mOhm.
        r_nom = (r >= 0.0) ? r
              : ((l_eff * w_eff * rsh > 0.0) ? (rsh * (l_eff - short) / (w_eff - narrow)) : 1.0e-3);

        // ── Temperature coefficient (restemp.c:79-94) ────────────────────────
        diff   = t - `NG_REFTEMP;
        factor = 1.0 + tc1 * diff + tc2 * diff * diff;

        // ── Conductance (restemp.c:96) ────────────────────────────────────────
        g_dc = 1.0 / (r_nom * factor * scale);

        // AC conductance (restemp.c:99-104) — used only in AC analysis (resacld.c)
        g_ac = (ac >= 0.0) ? (1.0 / (ac * factor * scale)) : g_dc;

        // ── DC / transient / AC contribution (resload.c:34-37, resacld.c:63-68)
        // I(p,n) = m . g . V(p,n); AC swaps in the acConduct value.
        g_now = $analysis("ac") ? g_ac : g_dc;
        I(p, n) <+ m * g_now * V(p, n);

        // ── Noise (resnoise.c:120-137) ────────────────────────────────────────
        // Thermal: 4kT.(m.G).  Flicker: m.KF.|I|^AF/f with I = G.V (no m inside).
        if (noisy) begin
            I(p, n) <+ white_noise(4.0 * `NG_K * t * m * g_dc);
            if (kf > 0.0) begin
                i_r = g_dc * V(p, n);
                I(p, n) <+ flicker_noise(m * kf * pow(abs(i_r), af), 1.0);
            end
        end
    end
endmodule

// ════════════════════════════════════════════════════════════════════════════
//  CAPACITOR  (ngspice `C` element, cap device)
//  Source: captemp.c, capload.c, capsetup.c
// ════════════════════════════════════════════════════════════════════════════

module cap (inout electrical p, inout electrical n);
    // ── Model-card parameters (formerly `CapModel`) ──────────────────────────
    parameter real cjsw      = 0.0;       // sidewall capacitance per perimeter (F/m)
    parameter real defWidth  = 10.0e-6;   // default width (m)
    parameter real defLength = 0.0;       // default length (m)
    parameter real narrow    = -1.0;      // width reduction (m); < 0 = derive from del
    parameter real short    = -1.0;      // length reduction (m); < 0 = derive from del
    parameter real del       = -1.0;      // process bias (m); narrows & shorts by 2*del; < 0 = not given
    parameter real tnom      = 300.15;    // nominal temperature (K)
    parameter real di        = -1.0;      // dielectric constant (relative eps_r); < 0 = not given
    parameter real thick     = -1.0;      // dielectric thickness (m); < 0 = not given
    parameter real bv_max    = -1.0;      // max voltage (SOA); < 0 = no limit (unused downstream, kept for API fidelity)

    // ── Instance parameters — `c`/`tc1`/`tc2` merged with their model-card
    //    namesakes (see file header). ──────────────────────────────────────
    parameter real cj     = -1.0;    // bottom capacitance per area (F/m^2); < 0 = derive from thick/di
    parameter real c      = -1.0;    // capacitance (F) override; < 0 = derive from geometry
    parameter real w      = -1.0;    // width (m); < 0 = defWidth
    parameter real l      = -1.0;    // length (m); < 0 = defLength
    parameter real ic     = 0.0;     // initial voltage (V) — see file header, NOT wired (codegen gap)
    parameter real temp   = -1.0;    // absolute temp (K); < 0 = ambient+dtemp
    parameter real dtemp  = 0.0;     // delta temp from ambient (K)
    parameter real scale  = 1.0;
    parameter real m      = 1.0;
    parameter real tc1    = 0.0;
    parameter real tc2    = 0.0;

    real t, w_eff, l_eff, nar, sho, cj_eff, c_nom, diff, factor, c_eff;

    analog begin
        // ── Temperature (captemp.c:39-47) — temp given => dtemp ignored ─────
        t = (temp >= 0.0) ? temp : ($temperature() + dtemp);

        // ── Width / length defaults (capsetup.c:95-101) ──────────────────────
        w_eff = (w >= 0.0) ? w : defWidth;
        l_eff = (l >= 0.0) ? l : defLength;

        // ── narrow / short from del (capsetup.c:83-88) ───────────────────────
        nar = (narrow >= 0.0) ? narrow : ((del >= 0.0) ? 2.0 * del : 0.0);
        sho = (short >= 0.0) ? short : ((del >= 0.0) ? 2.0 * del : 0.0);

        // ── cj derivation from thick/di (capsetup.c:71-81) ───────────────────
        cj_eff = (cj >= 0.0) ? cj
               : ((thick > 0.0) ? ((di >= 0.0) ? (di * `NG_EPS0 / thick) : (`NG_EPS_SIO2 / thick)) : 0.0);

        // ── Capacitance derivation (captemp.c:55-67) ──────────────────────────
        // Explicit c wins; else geometry.
        c_nom = (c >= 0.0) ? c
              : (cj_eff * (w_eff - nar) * (l_eff - sho) + cjsw * 2.0 * ((l_eff - sho) + (w_eff - nar)));

        // ── Temperature coefficient (captemp.c:69-77) ─────────────────────────
        diff   = t - tnom;
        factor = 1.0 + tc1 * diff + tc2 * diff * diff;

        // ── Effective capacitance (captemp.c:79) ──────────────────────────────
        // NOTE: ngspice does NOT multiply by m here; m is applied at stamp time.
        c_eff = c_nom * factor * scale;

        // ── Charge / current (capload.c:55-70) ────────────────────────────────
        // Q = C * V;  I = dQ/dt = m * C * dV/dt
        // In DC, ddt -> 0 (capacitor is open). OK.
        I(p, n) <+ m * ddt(c_eff * V(p, n));

        // ── Initial condition (capgetic.c, NGP-10) ────────────────────────────
        // ngspice: `ic` seeds the UIC start voltage across the capacitor.
        // NOT WIRED: see file header — a Potential UIC seed on a branch that
        // already carries this module's unconditional Flow contribution is
        // rejected by the elaborator (LRM Sec 5.4.2) regardless of
        // `@(initial_step)` guarding, and Contribution-inside-event-body has
        // no lowering path yet either way (T32). `ic` stays a declared,
        // unused parameter until a Flow/Potential-coexistence or dedicated
        // UIC-seed mechanism lands in codegen.
    end
endmodule

// ════════════════════════════════════════════════════════════════════════════
//  INDUCTOR  (ngspice `L` element, ind device)
//  Source: indtemp.c, indload.c, indsetup.c
//
//  FAITHFULNESS NOTE: ngspice divides stored L by m in indtemp.c AND again
//  in indload.c, giving L_eff = L / m^2.  This is the stock SPICE3f5
//  behaviour and is replicated here verbatim.
// ════════════════════════════════════════════════════════════════════════════

module ind (inout electrical p, inout electrical n);
    // ── Model-card parameters (formerly `IndModel`) — `nt`/`tc1`/`tc2` merged
    //    with their instance namesakes (see file header). ─────────────────
    parameter real csect  = 0.0;       // core cross-section (m^2)
    parameter real length = -1.0;      // magnetic path length (m); < 0 = not given
    parameter real mu     = -1.0;      // relative permeability; < 0 = not given (defaults to 1.0)

    // ── Instance parameters ──────────────────────────────────────────────
    parameter real l      = -1.0;    // inductance (H) override; < 0 = derive from geometry
    parameter real ic     = 0.0;     // initial current (A) — NOT wired, NGP-10 (ROADMAP.md), see below
    parameter real temp   = -1.0;
    parameter real dtemp  = 0.0;
    parameter real scale  = 1.0;
    parameter real m      = 1.0;
    parameter real nt     = 0.0;     // turn count (model default and instance override share one value)
    parameter real tc1    = 0.0;
    parameter real tc2    = 0.0;

    real t, spec_ind, l_nom, diff, factor, l_eff;

    analog begin
        // ── Temperature (indtemp.c:30-36) ─────────────────────────────────────
        t = (temp >= 0.0) ? temp : ($temperature() + dtemp);

        // ── Specific inductance from core geometry (indsetup.c:54-63) ─────────
        spec_ind = (length > 0.0) ? (((mu >= 0.0) ? mu : 1.0) * `NG_MU0 * csect * csect / length) : 0.0;

        // ── Inductance derivation (indtemp.c:38-46) ───────────────────────────
        l_nom = (l >= 0.0) ? l : (spec_ind * nt * nt);

        // ── Temperature coefficient (indtemp.c:48-54) ─────────────────────────
        diff   = t - `NG_REFTEMP;
        factor = 1.0 + tc1 * diff + tc2 * diff * diff;

        // ── Effective inductance (indtemp.c:56-57 + indload.c:92) ─────────────
        // ngspice quirk: L is divided by m in temp setup AND again in load.
        //   L_eff = L * factor * scale / m^2
        l_eff = l_nom * factor * scale / (m * m);

        // ── Constitutive relation: V = L * dI/dt (indload.c:97-124) ───────────
        // In DC, ddt -> 0, so V = 0 (inductor is a short). OK.
        V(p, n) <+ l_eff * ddt(I(p, n));

        // ── Initial condition (indload.c:39-42, UIC path) ─────────────────────
        // ngspice's `ind.IC` is a **current** seed (the device pre-computes
        // flux `L . I` and pins the inductor's internal state). Piperine's
        // UIC-seed mechanism only collects Potential seeds — wiring a current
        // seed needs a Flow-seed mechanism that is a separate codegen
        // feature; documented deviation, NGP-10 (`ROADMAP.md`,
        // `.specs/features/ngspice-parity/spec.md`). Carried over unchanged
        // from the PHDL predecessor, which likewise never emitted IC code
        // here — only this comment.
    end
endmodule

// ════════════════════════════════════════════════════════════════════════════
//  MUTUAL INDUCTOR  (ngspice `K` element, mut device)
//  Source: muttemp.c, indload.c:52-77 (mutual section)
//
//  In SPICE, K references two named inductors by name and adds cross-coupling
//  flux.  Here, `mut` takes the four terminals of the two inductors and the
//  two inductance values, and adds the mutual voltage contributions on top of
//  whatever the individual `ind` instances already force.
//
//  V1 += M * dI2/dt     V2 += M * dI1/dt     M = k * sqrt(L1 * L2)
// ════════════════════════════════════════════════════════════════════════════

module mut (
    inout electrical p1, inout electrical n1,
    inout electrical p2, inout electrical n2
);
    parameter real k  = 1.0;          // coupling coefficient
    parameter real l1 = 1.0e-6;       // inductance of L1 (H) — must match instance
    parameter real l2 = 1.0e-6;       // inductance of L2 (H) — must match instance

    real m_val;

    analog begin
        // ── Mutual inductance (muttemp.c) ─────────────────────────────────────
        m_val = k * sqrt(l1 * l2);

        // ── Cross-coupling (indload.c:56-60, 68-69) ────────────────────────────
        // Adds M * dI_other/dt to each inductor's branch voltage.
        V(p1, n1) <+ m_val * ddt(I(p2, n2));
        V(p2, n2) <+ m_val * ddt(I(p1, n1));
    end
endmodule

// ════════════════════════════════════════════════════════════════════════════
//  TRANSFORMER  (combined two-winding device — self + mutual in one element)
//
//  A convenience block that carries both winding self-inductances and their
//  mutual coupling, so a host does not have to wire two `ind` instances plus a
//  `mut`. The coupled-flux constitutive relations (indload.c mutual section):
//
//    Phi1 = L1*I1 + M*I2,   Phi2 = L2*I2 + M*I1,   M = k*sqrt(L1*L2)
//    V1 = dPhi1/dt,         V2 = dPhi2/dt
//
//  In AC with the secondary open, V2/V1 = M/L1 = k*sqrt(L2/L1) (-> the turns
//  ratio N2/N1 as k -> 1). In DC both windings are shorts (ddt -> 0).
//  |k| <= 1 required.
// ════════════════════════════════════════════════════════════════════════════

module xfmr (
    inout electrical p1, inout electrical n1,   // primary
    inout electrical p2, inout electrical n2    // secondary
);
    // PHDL's `$assert(l1 > 0.0, "...")`/etc. (a runtime call, PHDL-only —
    // VAMS has no `$assert`) become the real Verilog-A idiom for parameter
    // validity: a `from`/`exclude` range on the `parameter` declaration
    // itself (LRM Sec 3.4.2), checked once at elaboration against whatever
    // value the parameter resolves to (default or instance override) rather
    // than re-checked every analog evaluation. `l1`/`l2` only need a lower
    // bound (open at 0); the LRM permits an unbounded upper end via the
    // `inf` literal, but this codegen's elaboration-constant evaluator does
    // not resolve it yet, and separately `$finish` inside an analog body is
    // `CodegenError::Unsupported` here (both confirmed by direct test) — so
    // a runtime check is not an option either. 1e15 H is not a physically
    // meaningful upper bound, only a stand-in "large enough that no real
    // instance will ever hit it" until `inf`-in-range support lands.
    parameter real l1 = 1.0e-6 from (0:1e15);  // primary self-inductance (H), must be > 0
    parameter real l2 = 1.0e-6 from (0:1e15);  // secondary self-inductance (H), must be > 0
    parameter real k  = 0.999 from [-1:1];     // coupling coefficient, |k| <= 1

    real m_val;

    analog begin
        m_val = k * sqrt(l1 * l2);

        // Each branch voltage is the time-derivative of its coupled flux —
        // self-term plus the mutual term from the other winding's current.
        V(p1, n1) <+ l1 * ddt(I(p1, n1)) + m_val * ddt(I(p2, n2));
        V(p2, n2) <+ l2 * ddt(I(p2, n2)) + m_val * ddt(I(p1, n1));
    end
endmodule
