// NGSPICE faithful model — diode.
//
// Source: ngspice/src/spicelib/devices/dio/
//   diodefs.h   diotemp.c   dioload.c   dioparam.c   diompar.c   dionoise.c
//
// Includes: series resistance (internal node), bottom + sidewall junctions,
// tunneling, breakdown, high-level injection (IKF/IKR), depletion + diffusion
// charge, temperature dependence (tlev/tlevc), shot + flicker noise.
//
// All equations are translated line-by-line from the C source, same as the
// PHDL predecessor this file replaces (T42, VAMS-08 — a dialect rewrite,
// not a re-derivation).
//
// PHDL's top-level `pub fn ng_dio_bv_step(...)` (the one step of ngspice's
// breakdown-voltage fixed-point iteration, diotemp.c:232-238) has no VAMS
// Annex A production to migrate to — Verilog-A has no module-external
// function scope (LRM Sec 4.7/5.9) and this codegen does not lower
// user-defined `analog function` calls into the POM either way (T41's
// `sources.va` header, MD-45) — so the 24-step fixed-point unroll is inlined
// straight-line, one assignment per original call, same iteration count.
//
// PHDL's `bundle DioModel` (model-card) flattens into ordinary module
// `parameter`s (T41 convention, `passives.va`). ONE genuine name collision
// falls out of the flattening: the model-card's grading-coefficient field
// `model.m` and the instance-level parallel-multiplier `param m` share the
// bare name `m` only because PHDL kept them in separate `model.`/bare
// namespaces — they are different physical quantities (grading exponent vs.
// device count) and VAMS has one flat parameter namespace, so the model-card
// field is renamed `grad_m` here; every other field is a straight rename.
// `Real?`/`.is_present()`/`.get_or()` (`ns`, `nbv`, `bv` — sidewall emission
// coefficient, breakdown emission coefficient, breakdown voltage) become the
// same negative-sentinel convention T41 established (`parameter real x =
// -1.0`, `x >= 0.0` stands in for "was given") since none of the three is
// ever legitimately negative. PHDL's `dest <- src` (`BindOp::Force`, T32's
// documented SPEC_DEVIATION) becomes `<+` throughout — every `<-` site here
// is an unconditional single contribution to its own branch, so the
// substitution is exact.
//
// UIC seed: `dio`'s `@ initial { V(p,n) <- ic; }` seeds the IMPLICIT branch
// (p,n) — a different branch from (p,pp) (series-resistance drop) and
// (pp,n) (the junction's Flow contribution), so unlike `cap`/`ind` this is
// NOT a same-branch potential/flow conflict (NGP-10, `passives.va`).
// Confirmed by direct compile it still cannot be wired: `AnalogKernel::
// compile` rejects ANY Potential contribution inside an event-control body
// (`Unsupported("conditional potential contribution")`) — a lowering gap
// unconditional on branch conflict. `ic` stays a declared, unused
// parameter; see the disposition at its former call site below.
//
// The SOA constraint block (dv-core T27, DVC-16) is restored as a
// `constraint begin … end` block at the model's foot (constraints-on-vams,
// MD-49): `fv_max`/`bv_max` are live again, absent-by-default sentinels
// (`if_max` stays declared for API fidelity — a current probe needs the
// branch form the block grammar reads through V() only today).
// ════════════════════════════════════════════════════════════════════════════

`include "disciplines.vams"
`include "constants.va"

module dio (inout electrical p, inout electrical n);
    // ── Model-card parameters (formerly `DioModel`) ──────────────────────────
    parameter real is     = 1.0e-14;   // saturation current (A)
    parameter real n_e    = 1.0;       // emission coefficient (PHDL `model.n`; `n` is the port)
    parameter real rs     = 0.0;       // ohmic series resistance (Ohm)
    parameter real ikf    = 0.0;       // forward knee current (A) — high-level injection
    parameter real ikr    = 0.0;       // reverse knee current (A)
    parameter real ns     = -1.0;      // sidewall emission coeff; < 0 = not given (own sidewall diode)
    parameter real jsw    = 0.0;       // sidewall saturation current (A)
    parameter real nbv    = -1.0;      // breakdown emission coeff; < 0 = use n_e

    parameter real bv     = -1.0;      // breakdown voltage (V); < 0 = not given
    parameter real ibv    = 1.0e-3;    // breakdown current (A)

    parameter real tt     = 0.0;       // transit time (s)
    parameter real cjo    = 0.0;       // zero-bias junction cap (F)
    parameter real vj     = 1.0;       // junction potential (V)
    parameter real grad_m = 0.5;       // grading coefficient (PHDL `model.m`)
    parameter real cjsw   = 0.0;       // sidewall junction cap (F)
    parameter real vjsw   = 1.0;       // sidewall junction potential (V)
    parameter real mjsw   = 0.33;      // sidewall grading coefficient
    parameter real fc     = 0.5;       // depletion cap coeff (forward-bias fit)
    parameter real fcs    = 0.5;       // sidewall depletion cap coeff

    parameter real jtun   = 0.0;       // tunneling saturation current (A)
    parameter real jtunsw = 0.0;       // sidewall tunneling saturation current (A)
    parameter real ntun   = 30.0;      // tunneling emission coefficient
    parameter real xtitun = 3.0;       // tunneling sat-current temp exponent
    parameter real keg    = 1.0;       // EG correction factor for tunneling

    parameter real eg     = 1.11;      // activation energy (eV)
    parameter real xti    = 3.0;       // sat-current temp exponent
    parameter real tnom   = 300.15;    // nominal temperature (K)
    parameter real tlev   = 0.0;       // temp-equation selector (0,1,3)
    parameter real tlevc  = 0.0;       // cap/potential temp-equation selector (0,1)
    parameter real tcv    = 0.0;       // breakdown voltage temp coefficient
    parameter real cta    = 0.0;       // area junction cap temp coeff (tlevc=1)
    parameter real ctp    = 0.0;       // perimeter junction cap temp coeff (tlevc=1)
    parameter real tpb    = 0.0;       // area junction potential temp coeff (tlevc=1)
    parameter real tphp   = 0.0;       // perimeter junction potential temp coeff (tlevc=1)
    parameter real tm1    = 0.0;       // grading coeff 1st temp coeff
    parameter real tm2    = 0.0;       // grading coeff 2nd temp coeff
    parameter real ttt1   = 0.0;       // transit time 1st temp coeff
    parameter real ttt2   = 0.0;       // transit time 2nd temp coeff
    parameter real trs1   = 0.0;       // series resistance 1st temp coeff
    parameter real trs2   = 0.0;       // series resistance 2nd temp coeff

    parameter real kf     = 0.0;       // flicker noise coefficient
    parameter real af     = 1.0;       // flicker noise exponent

    // SOA (DVC-16, T27) — read by the model's constraint block; sentinel
    // defaults keep the checks vacuous until overridden.
    parameter real fv_max = 1.0e99;    // forward voltage SOA cap (V)
    parameter real bv_max = 1.0e99;    // reverse breakdown SOA cap (V)
    parameter real if_max = 1.0e99;    // forward current SOA cap (A)

    // ── Instance parameters ───────────────────────────────────────────────
    parameter real area  = 1.0;      // area factor
    parameter real pj    = 0.0;      // perimeter
    parameter real m     = 1.0;      // parallel multiplier
    parameter real temp  = 0.0;      // absolute temp (K); 0 = ambient
    parameter real dtemp = 0.0;      // delta temp (K)
    parameter real ic    = 0.0;      // initial voltage (V)
    parameter integer off = 0;       // initially off (advisory, unused)

    // Internal node for series resistance (diodefs.h: DIOposPrimeNode)
    electrical pp;

    real t, dt, vt, vtnom, eg_c, fc_c, fcs_c, ns_eff, nbv_eff, area_eff, pj_eff;
    real fact1, fact2, egfet, egfet1, arg, pbfact, arg1, pbfact1, xfc, xfcs;
    real m0, tM, tJctPot, tJctCap, pbo, gmaold, gmanew;
    real tJctSWPot, tJctSWCap, pboSW, gmaSWold, gmaSWnew;
    real tSatCur, tSatSWCur, tTunSatCur, tTunSatSWCur;
    real tF1, tDepCap, tDepSWCap, vte, tVcrit, tF2, tF3, tF2SW, tF3SW;
    real tTransitTime, tConductance, rs_factor, gspr;
    real tBrkdwnV, tBv, cbv, xbv, vtebrk, rseries, vd, gmin;
    real csat, csatsw, cdsw, gdsw, vtesw, evd, argsw, evrev, cdb, gdb, vtetun;
    real ikf_area_m, ikr_area_m, sqrt_ikf, sqrt_ikr;
    real cd, gd, qdepl, sarg, czof2, qdeplSW, argSW, sargSW, czof2SW, qdiff, qtotal;

    analog begin
        // ════════════════════════════════════════════════════════════════════
        //  Sec1  Temperature preprocessing  (diotemp.c)
        // ════════════════════════════════════════════════════════════════════
        t = (temp > 0.0) ? temp : ($temperature() + dtemp);
        dt = t - tnom;
        vt = $vt(t);
        vtnom = $vt(tnom);

        // Parameter clamps (diotemp.c:41-68)
        eg_c  = max(eg, 0.1);
        fc_c  = min(fc, 0.95);
        fcs_c = min(fcs, 0.95);
        ns_eff = (ns >= 0.0) ? ns : 1.0;
        nbv_eff = (nbv >= 0.0) ? nbv : n_e;

        // m folded into area and perimeter (parallel diodes)
        area_eff = area * m;
        pj_eff   = pj * m;

        // Bandgap / pbfact precomputation (diotemp.c:107-118)
        fact1  = tnom / `NG_REFTEMP;
        fact2  = t / `NG_REFTEMP;
        egfet  = 1.16 - (7.02e-4 * t * t) / (t + 1108.0);
        egfet1 = 1.16 - (7.02e-4 * tnom * tnom) / (tnom + 1108.0);
        arg    = 0.0 - egfet / (2.0 * `NG_K * t) + 1.1150877 / (2.0 * `NG_K * `NG_REFTEMP);
        pbfact = 0.0 - 2.0 * vt * (1.5 * ln(fact2) + `NG_Q * arg);
        arg1   = 0.0 - egfet1 / (2.0 * `NG_K * tnom) + 1.1150877 / (2.0 * `NG_K * `NG_REFTEMP);
        pbfact1= 0.0 - 2.0 * vtnom * (1.5 * ln(fact1) + `NG_Q * arg1);

        xfc  = ln(1.0 - fc_c);
        xfcs = ln(1.0 - fcs_c);

        // ── Grading coefficient temp adjust (diotemp.c:41-47, 90-102) ────────
        m0 = min(grad_m, 0.9);
        tM = m0 * (1.0 + tm1 * dt + tm2 * dt * dt);
        if (tM > 0.9) begin
            tM = 0.9;
        end

        // ── Bottom junction cap/potential (diotemp.c:120-129, tlevc=0) ───────
        if (tlevc == 0.0) begin
            pbo = (vj - pbfact1) / fact1;
            gmaold = (vj - pbo) / pbo;
            tJctCap = cjo * area_eff / (1.0 + tM * (4.0e-4 * (tnom - `NG_REFTEMP) - gmaold));
            tJctPot = pbfact + fact2 * pbo;
            gmanew = (tJctPot - pbo) / pbo;
            tJctCap = tJctCap * (1.0 + tM * (4.0e-4 * (t - `NG_REFTEMP) - gmanew));
        end else begin
            tJctPot = vj - tpb * (t - `NG_REFTEMP);
            tJctCap = cjo * area_eff * (1.0 + cta * (t - `NG_REFTEMP));
        end

        // ── Sidewall junction cap/potential (diotemp.c:136-150, tlevc=0) ─────
        if (tlevc == 0.0) begin
            pboSW = (vjsw - pbfact1) / fact1;
            gmaSWold = (vjsw - pboSW) / pboSW;
            tJctSWCap = cjsw * pj_eff / (1.0 + mjsw * (4.0e-4 * (tnom - `NG_REFTEMP) - gmaSWold));
            tJctSWPot = pbfact + fact2 * pboSW;
            gmaSWnew = (tJctSWPot - pboSW) / pboSW;
            tJctSWCap = tJctSWCap * (1.0 + mjsw * (4.0e-4 * (t - `NG_REFTEMP) - gmaSWnew));
        end else begin
            tJctSWPot = vjsw - tphp * (t - `NG_REFTEMP);
            tJctSWCap = cjsw * pj_eff * (1.0 + ctp * (t - `NG_REFTEMP));
        end

        // ── Saturation currents (diotemp.c:152-172) ───────────────────────────
        tSatCur = is * area_eff * exp(
            ((t / tnom) - 1.0) * eg_c / (n_e * vt) +
            xti / n_e * ln(t / tnom)
        );
        tSatSWCur = jsw * pj_eff * exp(
            ((t / tnom) - 1.0) * eg_c / (ns_eff * vt) +
            xti / ns_eff * ln(t / tnom)
        );
        tTunSatCur = jtun * area_eff * exp(
            ((t / tnom) - 1.0) * keg * eg_c / vt +
            xtitun * ln(t / tnom)
        );
        tTunSatSWCur = jtunsw * pj_eff * exp(
            ((t / tnom) - 1.0) * keg * eg_c / vt +
            xtitun * ln(t / tnom)
        );

        // ── Capacitance precomputation (diotemp.c:176-183, 260-265) ──────────
        // NOTE: ngspice computes only ONE tF1 (from the bottom junction); the
        // sidewall depletion charge reuses it (dioload.c:328).
        tF1       = tJctPot * (1.0 - exp((1.0 - tM) * xfc)) / (1.0 - tM);
        tDepCap   = fc_c * tJctPot;
        tDepSWCap = fcs_c * tJctSWPot;

        // ── Vcrit (diotemp.c:185-187) ──────────────────────────────────────────
        vte = n_e * vt;
        tVcrit = vte * ln(vte / (`NG_SQRT2 * tSatCur));

        // ── Junction potential limits (diotemp.c:189-204) ─────────────────────
        if (tDepCap > 1.0) begin
            tJctPot = 1.0 / fc_c;
            tDepCap = fc_c * tJctPot;
        end
        if (tDepSWCap > 1.0) begin
            tJctSWPot = 1.0 / fcs_c;
            tDepSWCap = fcs_c * tJctSWPot;
        end

        // ── F2/F3 factors (diotemp.c:260-265) ──────────────────────────────────
        tF2   = exp((1.0 + tM) * xfc);
        tF3   = 1.0 - fc_c * (1.0 + tM);
        tF2SW = exp((1.0 + mjsw) * xfcs);
        tF3SW = 1.0 - fcs_c * (1.0 + mjsw);

        // ── Transit time temp adjust (diotemp.c:248-250) ───────────────────────
        tTransitTime = tt * (1.0 + ttt1 * dt + ttt2 * dt * dt);

        // ── Series resistance temp adjust (diotemp.c:253-258) ──────────────────
        tConductance = 0.0;
        if (rs > 0.0) begin
            rs_factor = 1.0 + trs1 * dt + trs2 * dt * dt;
            tConductance = (1.0 / rs) / rs_factor;
        end
        gspr = tConductance * area_eff;

        // ── Breakdown voltage temp adjust (diotemp.c:208-244) ──────────────────
        // ngspice matches the forward and reverse regions with a fixed-point
        // iteration (25 steps max). Verilog-A has no loops that would keep this
        // strictly combinational for the JIT, so the iteration is unrolled
        // (24 straight-line reassignments) — extra steps past convergence are
        // no-ops on the fixed point.
        tBrkdwnV = 0.0;   // set from bv when present; unread otherwise
        if (bv >= 0.0) begin
            tBv = (tlev == 0.0) ? (bv - tcv * dt) : (bv * (1.0 - tcv * dt));
            cbv = ibv;  // level 1
            if (cbv < tSatCur * tBv / vt) begin
                // cbv raised to tSatCur*tBv/vt; xbv = tBv (diotemp.c:219-226)
                tBrkdwnV = tBv;
            end else begin
                xbv = tBv - nbv_eff * vt * ln(1.0 + cbv / tSatCur);
                xbv = tBv - (nbv_eff * vt) * ln(cbv / tSatCur + 1.0 - xbv / vt);
                xbv = tBv - (nbv_eff * vt) * ln(cbv / tSatCur + 1.0 - xbv / vt);
                xbv = tBv - (nbv_eff * vt) * ln(cbv / tSatCur + 1.0 - xbv / vt);
                xbv = tBv - (nbv_eff * vt) * ln(cbv / tSatCur + 1.0 - xbv / vt);
                xbv = tBv - (nbv_eff * vt) * ln(cbv / tSatCur + 1.0 - xbv / vt);
                xbv = tBv - (nbv_eff * vt) * ln(cbv / tSatCur + 1.0 - xbv / vt);
                xbv = tBv - (nbv_eff * vt) * ln(cbv / tSatCur + 1.0 - xbv / vt);
                xbv = tBv - (nbv_eff * vt) * ln(cbv / tSatCur + 1.0 - xbv / vt);
                xbv = tBv - (nbv_eff * vt) * ln(cbv / tSatCur + 1.0 - xbv / vt);
                xbv = tBv - (nbv_eff * vt) * ln(cbv / tSatCur + 1.0 - xbv / vt);
                xbv = tBv - (nbv_eff * vt) * ln(cbv / tSatCur + 1.0 - xbv / vt);
                xbv = tBv - (nbv_eff * vt) * ln(cbv / tSatCur + 1.0 - xbv / vt);
                xbv = tBv - (nbv_eff * vt) * ln(cbv / tSatCur + 1.0 - xbv / vt);
                xbv = tBv - (nbv_eff * vt) * ln(cbv / tSatCur + 1.0 - xbv / vt);
                xbv = tBv - (nbv_eff * vt) * ln(cbv / tSatCur + 1.0 - xbv / vt);
                xbv = tBv - (nbv_eff * vt) * ln(cbv / tSatCur + 1.0 - xbv / vt);
                xbv = tBv - (nbv_eff * vt) * ln(cbv / tSatCur + 1.0 - xbv / vt);
                xbv = tBv - (nbv_eff * vt) * ln(cbv / tSatCur + 1.0 - xbv / vt);
                xbv = tBv - (nbv_eff * vt) * ln(cbv / tSatCur + 1.0 - xbv / vt);
                xbv = tBv - (nbv_eff * vt) * ln(cbv / tSatCur + 1.0 - xbv / vt);
                xbv = tBv - (nbv_eff * vt) * ln(cbv / tSatCur + 1.0 - xbv / vt);
                xbv = tBv - (nbv_eff * vt) * ln(cbv / tSatCur + 1.0 - xbv / vt);
                xbv = tBv - (nbv_eff * vt) * ln(cbv / tSatCur + 1.0 - xbv / vt);
                xbv = tBv - (nbv_eff * vt) * ln(cbv / tSatCur + 1.0 - xbv / vt);
                tBrkdwnV = xbv;
            end
        end

        vtebrk = nbv_eff * vt;

        // ════════════════════════════════════════════════════════════════════
        //  Sec2  Series resistance  (dioload.c:422-428)
        // ════════════════════════════════════════════════════════════════════
        // ngspice collapses the internal node when RS == 0 (diosetup.c);
        // this keeps the node and forces the series drop instead — `V = R.I`
        // over the force's own branch is a series resistor, and R = 0 a
        // perfect short. (A conditional `V <+ 0` would lower to the JIT's
        // penalty-conductance form, whose 1e12 stamp destroys current accuracy
        // below ~1e-4 A — found by the diode_iv ngspice sweep.)
        rseries = (rs > 0.0) ? (1.0 / gspr) : 0.0;
        V(p, pp) <+ rseries * I(p, pp);

        // ════════════════════════════════════════════════════════════════════
        //  Sec3  Junction voltage  (dioload.c:148-191)
        // ════════════════════════════════════════════════════════════════════
        vd = V(pp, n);

        // Voltage limiting for convergence (dioload.c:180-191, DEVpnjlim)
        if (bv >= 0.0 && vd < min(0.0, 0.0 - tBrkdwnV + 10.0 * vtebrk)) begin
            vd = 0.0 - ($limit("pnjlim", 0.0 - (vd + tBrkdwnV), 0.0, vtebrk, tVcrit) + tBrkdwnV);
        end else begin
            vd = $limit("pnjlim", vd, 0.0, vte, tVcrit);
        end

        gmin = $simparam("gmin", 1.0e-12);

        // ════════════════════════════════════════════════════════════════════
        //  Sec4  Sidewall diode current  (dioload.c:196-230)
        //  ngspice: the sidewall gets its OWN characteristic only when NS was
        //  explicitly given; otherwise the sidewall saturation current is
        //  merged into the bottom diode (csat += csatsw) and follows the
        //  bottom's N.
        // ════════════════════════════════════════════════════════════════════
        csat = tSatCur;
        csatsw = tSatSWCur;
        cdsw = 0.0;
        gdsw = 0.0;

        if (jsw > 0.0) begin
            if (ns >= 0.0) begin
                // Sidewall with its own characteristic (dioload.c:198-222)
                vtesw = ns_eff * vt;

                if (vd >= 0.0 - 3.0 * vtesw) begin
                    evd = limexp(vd / vtesw);
                    cdsw = csatsw * (evd - 1.0);
                    gdsw = csatsw * evd / vtesw;
                end else if (bv < 0.0 || vd >= 0.0 - tBrkdwnV) begin
                    argsw = 3.0 * vtesw / (vd * `NG_E);
                    argsw = argsw * argsw * argsw;
                    cdsw = 0.0 - csatsw * (1.0 + argsw);
                    gdsw = csatsw * 3.0 * argsw / vd;
                end else begin
                    evrev = limexp(0.0 - (tBrkdwnV + vd) / vtebrk);
                    cdsw = 0.0 - csatsw * evrev;
                    gdsw = csatsw * evrev / vtebrk;
                end
            end else begin
                // Merge into the bottom diode (dioload.c:224-228)
                csat = csat + csatsw;
            end
        end

        // ════════════════════════════════════════════════════════════════════
        //  Sec5  Bottom diode current  (dioload.c:232-252)
        // ════════════════════════════════════════════════════════════════════
        cdb = 0.0;
        gdb = 0.0;

        if (vd >= 0.0 - 3.0 * vte) begin
            // Forward region
            evd = limexp(vd / vte);
            cdb = csat * (evd - 1.0);
            gdb = csat * evd / vte;
        end else if (bv < 0.0 || vd >= 0.0 - tBrkdwnV) begin
            // Reverse region — cubic extension (dioload.c:241-244)
            arg = 3.0 * vte / (vd * `NG_E);
            arg = arg * arg * arg;
            cdb = 0.0 - csat * (1.0 + arg);
            gdb = csat * 3.0 * arg / vd;
        end else begin
            // Breakdown region (dioload.c:246-250)
            evrev = limexp(0.0 - (tBrkdwnV + vd) / vtebrk);
            cdb = 0.0 - csat * evrev;
            gdb = csat * evrev / vtebrk;
        end

        // ════════════════════════════════════════════════════════════════════
        //  Sec6  Tunneling currents  (dioload.c:254-272)
        // ════════════════════════════════════════════════════════════════════
        if (jtunsw > 0.0) begin
            vtetun = ntun * vt;
            evd = limexp(0.0 - vd / vtetun);
            cdsw = cdsw - tTunSatSWCur * (evd - 1.0);
            gdsw = gdsw + tTunSatSWCur * evd / vtetun;
        end

        if (jtun > 0.0) begin
            vtetun = ntun * vt;
            evd = limexp(0.0 - vd / vtetun);
            cdb = cdb - tTunSatCur * (evd - 1.0);
            gdb = gdb + tTunSatCur * evd / vtetun;
        end

        // ════════════════════════════════════════════════════════════════════
        //  Sec7  Total current + knee current + gmin  (dioload.c:274-301)
        // ════════════════════════════════════════════════════════════════════
        cd = cdb + cdsw;
        gd = gdb + gdsw;

        // ngspice scales IKF/IKR by area.m (diosetup.c:193-194)
        ikf_area_m = ikf * area_eff;
        ikr_area_m = ikr * area_eff;

        if (vd >= 0.0 - 3.0 * vte) begin
            // Forward — IKF high-level injection (dioload.c:279-283)
            if (ikf > 0.0 && cd > 1.0e-18) begin
                sqrt_ikf = sqrt(cd / ikf_area_m);
                cd = cd / (1.0 + sqrt_ikf) + gmin * vd;
            end else begin
                cd = cd + gmin * vd;
            end
        end else begin
            // Reverse — IKR (dioload.c:291-295)
            if (ikr > 0.0 && cd < 0.0 - 1.0e-18) begin
                sqrt_ikr = sqrt(cd / (0.0 - ikr_area_m));
                cd = cd / (1.0 + sqrt_ikr) + gmin * vd;
            end else begin
                cd = cd + gmin * vd;
            end
        end

        // ════════════════════════════════════════════════════════════════════
        //  Sec8  Charge storage  (dioload.c:303-341)
        // ════════════════════════════════════════════════════════════════════
        // Bottom depletion charge
        if (vd < tDepCap) begin
            arg = 1.0 - vd / tJctPot;
            sarg = exp(0.0 - tM * ln(arg));
            qdepl = tJctPot * tJctCap * (1.0 - arg * sarg) / (1.0 - tM);
        end else begin
            czof2 = tJctCap / tF2;
            qdepl = tJctCap * tF1 + czof2 * (
                tF3 * (vd - tDepCap) +
                (tM / (tJctPot + tJctPot)) * (vd * vd - tDepCap * tDepCap)
            );
        end

        // Sidewall depletion charge — always stamped when CJSW > 0
        // (dioload.c:320-331). NOTE: ngspice reuses the BOTTOM junction's tF1
        // here (there is no tF1SW).
        qdeplSW = 0.0;
        if (cjsw > 0.0) begin
            if (vd < tDepSWCap) begin
                argSW = 1.0 - vd / tJctSWPot;
                sargSW = exp(0.0 - mjsw * ln(argSW));
                qdeplSW = tJctSWPot * tJctSWCap * (1.0 - argSW * sargSW) / (1.0 - mjsw);
            end else begin
                czof2SW = tJctSWCap / tF2SW;
                qdeplSW = tJctSWCap * tF1 + czof2SW * (
                    tF3SW * (vd - tDepSWCap) +
                    (mjsw / (tJctSWPot + tJctSWPot)) * (vd * vd - tDepSWCap * tDepSWCap)
                );
            end
        end

        // Diffusion charge (dioload.c:333-334)
        qdiff = tTransitTime * (cdb + cdsw);

        qtotal = qdiff + qdepl + qdeplSW;

        // ════════════════════════════════════════════════════════════════════
        //  Sec9  Contributions  (dioload.c:416-428)
        // ════════════════════════════════════════════════════════════════════
        // DC current + capacitive current
        I(pp, n) <+ cd;
        I(pp, n) <+ ddt(qtotal);

        // ════════════════════════════════════════════════════════════════════
        //  Sec10  Noise  (dionoise.c:104-117)
        // ════════════════════════════════════════════════════════════════════
        // Series-resistance thermal noise: 4kT . tConductance.area.m^2 —
        // ngspice multiplies the (already m-scaled) area by m again here;
        // replicated as-is.
        // NOTE (T42 translation finding, not in the PHDL predecessor): the
        // series-resistance branch (p,pp) already carries an unconditional
        // Potential contribution (`V(p,pp) <+ rseries*I(p,pp)`, the R=0-safe
        // Force form above). A Flow-type noise contribution on the SAME
        // branch — `I(p,pp) <+ white_noise(...)`, PHDL's literal predecessor
        // — trips LRM Sec 5.4.2's "not both potential and flow" rule (PHDL's
        // `<-` Force was exempt from this check; real Verilog-A `<+` is not,
        // confirmed by direct elaboration failure). The fix is not a
        // numeric approximation: a resistor's Norton current-noise source
        // (PSD 4kT.G, parallel) and its Thevenin voltage-noise source
        // (PSD 4kT.R = 4kT/G, series) are the textbook-equivalent
        // representations of the same physical noise, so the contribution
        // is re-expressed as Potential (`V <+`) with PSD 4kT.R — same branch
        // type as the deterministic stamp, same physics, exact conversion
        // (R = rseries = 1/gspr here). Every other RS/RD-style series-
        // resistance noise source in `bjt`/`jfet`/`mos.va` carries the same
        // conversion for the same reason. The `if (rs > 0.0)` guard PHDL had
        // is dropped too: any conditional Potential contribution is
        // separately unsupported (`flatten/analog.rs`'s "genuinely
        // guarded/conditional potential contribution" — confirmed by direct
        // compile), and it is not needed anyway — `rseries` is already 0
        // when `rs <= 0`, so the unconditional PSD is `white_noise(0.0)`
        // (no noise), the same outcome the guard produced.
        V(p, pp) <+ white_noise(4.0 * `NG_K * t * m * rseries);
        // Shot noise: 2*q*|Id|
        I(pp, n) <+ white_noise(2.0 * `NG_Q * abs(cd));
        // Flicker noise: m . KF . |Id/m|^AF / f  (dionoise.c:111-117)
        if (kf > 0.0) begin
            I(pp, n) <+ flicker_noise(m * kf * pow(abs(cd / m), af), 1.0);
        end

        // ── Initial condition (diogetic.c, NGP-10) ─────────────────────────────
        // ngspice: `ic` seeds the UIC start voltage across the junction.
        // NOT WIRED: confirmed by direct compile that `(p,n)` carrying no
        // OTHER contribution does not save this — `AnalogKernel::compile`
        // rejects ANY Potential contribution inside an event-control body
        // (`Unsupported("conditional potential contribution")`), regardless
        // of branch-conflict status. This is the same "Contribution inside
        // an event body has no lowering path" gap `passives.va`'s header
        // documents for `cap`/`ind` (NGP-10) — here it fires for a different
        // underlying reason (no lowering path for the construct at all, not
        // a branch-type conflict), so `ic` stays a declared, unused
        // parameter rather than shipped broken.
    end
    // ── SOA limits (dv-core T27 restored): directional junction checks,
    // absent by default — the sentinels keep them vacuously satisfied
    // until an instance override names real limits. ─────────────────────
    constraint begin
        require fwd_soa : V(p, n) <= fv_max;
        require rev_soa : V(p, n) >= -bv_max;
    end
endmodule
