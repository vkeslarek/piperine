// NGSPICE faithful models — independent sources.
//
// Source: ngspice/src/spicelib/devices/{vsrc,isrc}/
//   vsrcdefs.h  vsrcload.c  vsrcparam.c  vsrctemp.c
//   isrcdefs.h  isrcload.c  isrcparam.c  isrctemp.c
//
// VSRC = voltage source (V element) — forces V(p,n) = waveform(t)
// ISRC = current source (I element) — injects I(p,n) = m * waveform(t)
//
// Waveforms: DC, AC (small-signal), SIN, PULSE, EXP, SFFM, AM.
// All formulas translated from vsrcload.c.  The waveform defaults (step,
// tfinal) are read via $simparam.
//
// Mechanical dialect rewrite of the PHDL predecessor this file replaces
// (T41, VAMS-08), values/equations unchanged. PHDL's waveform helpers
// (`ng_sin`/`ng_pulse`/`ng_exp`/`ng_sffm`/`ng_am`/`ng_deg2rad`) were
// top-level `fn`s shared by `vsrc` and `isrc`; Verilog-A has no top-level
// (module-external) function scope (LRM Sec 4.7/5.9: "All functions are
// defined within modules") and this codegen does not lower user-defined
// `analog function`/`function` calls into the POM yet either way (MD-45),
// so each helper is inlined directly into both `vsrc`'s and `isrc`'s analog
// block rather than factored out — duplicated, not shared, same as any
// real single-file Verilog-A model would have to. Each helper's early
// `return`s (not a VAMS statement outside a function) become straight-line
// `if`/`else` assignments to one `val`, one branch per original `return`,
// same case order and same expressions.
// ════════════════════════════════════════════════════════════════════════════

`include "disciplines.vams"
`include "constants.vams"

// ════════════════════════════════════════════════════════════════════════════
//  VSRC — voltage source
// ════════════════════════════════════════════════════════════════════════════

module vsrc (inout electrical p, inout electrical n);
    parameter real dc       = 0.0;        // DC value (V)
    parameter real ac_mag   = 0.0;        // AC magnitude
    parameter real ac_phase = 0.0;        // AC phase (degrees)

    // Waveform selector: 0=dc, 1=sin, 2=pulse, 3=exp, 4=sffm, 5=am, 6=pwl
    parameter integer wave = 0;

    // SIN params (0 sentinels resolve to ngspice defaults: freq -> 1/tstop)
    parameter real sin_vo    = 0.0;
    parameter real sin_va    = 1.0;
    parameter real sin_freq  = 0.0;
    parameter real sin_td    = 0.0;
    parameter real sin_theta = 0.0;
    parameter real sin_phase = 0.0;   // degrees (XSPICE extension; 0 = classic)

    // PULSE params (tr/tf -> tstep, pw/per -> tstop when 0)
    parameter real pulse_v1  = 0.0;
    parameter real pulse_v2  = 1.0;
    parameter real pulse_td  = 0.0;
    parameter real pulse_tr  = 0.0;
    parameter real pulse_tf  = 0.0;
    parameter real pulse_pw  = 0.0;
    parameter real pulse_per = 0.0;

    // EXP params (td1/tau1/tau2 -> tstep, td2 -> td1+tstep when 0)
    parameter real exp_v1   = 0.0;
    parameter real exp_v2   = 1.0;
    parameter real exp_td1  = 0.0;
    parameter real exp_tau1 = 0.0;
    parameter real exp_td2  = 0.0;
    parameter real exp_tau2 = 0.0;

    // SFFM params (fc/fs -> 1/tstop when 0)
    parameter real sffm_vo  = 0.0;
    parameter real sffm_va  = 1.0;
    parameter real sffm_fc  = 0.0;
    parameter real sffm_mdi = 0.0;
    parameter real sffm_fs  = 0.0;

    // AM params (mf -> 1/tstop when 0)
    parameter real am_va = 1.0;
    parameter real am_vo = 0.0;
    parameter real am_mf = 0.0;
    parameter real am_fc = 0.0;
    parameter real am_td = 0.0;

    // PWL(t0,v0 t1,v1 ... t7,v7) — LRM Annex E Table E.1's `vpwl`/`ipwl`
    // (T58, LRMC-C10-17). ngspice's real PWL source takes an arbitrary-
    // length breakpoint list; this Verilog-A codegen has no array-
    // parameter support (SPEC_DEVIATION, disclosed: `annex_e.rs`'s own
    // note on this gap) so this is a fixed 8-point PWL instead — the
    // widest structural approximation reachable with scalar parameters.
    // Points must be strictly increasing (pwl_t0 < pwl_t1 < ... < pwl_t7);
    // before pwl_t0 the value holds at pwl_v0, after pwl_t7 it holds at
    // pwl_v7 (ngspice isrcload.c/vsrcload.c's own PWL before-first/after-
    // last behavior).
    parameter real pwl_t0 = 0.0;
    parameter real pwl_v0 = 0.0;
    parameter real pwl_t1 = 1.0;
    parameter real pwl_v1 = 0.0;
    parameter real pwl_t2 = 2.0;
    parameter real pwl_v2 = 0.0;
    parameter real pwl_t3 = 3.0;
    parameter real pwl_v3 = 0.0;
    parameter real pwl_t4 = 4.0;
    parameter real pwl_v4 = 0.0;
    parameter real pwl_t5 = 5.0;
    parameter real pwl_v5 = 0.0;
    parameter real pwl_t6 = 6.0;
    parameter real pwl_v6 = 0.0;
    parameter real pwl_t7 = 7.0;
    parameter real pwl_v7 = 0.0;

    real t, tstep, tstop, val, vval;
    real tp, phase_rad;                       // ng_sin scratch
    real freq;                                // wave==1 scratch
    real tr, tf, pw, per;                     // wave==2 scratch
    real td1, tau1, td2, tau2;                // wave==3 scratch
    real fc, fs;                              // wave==4 scratch
    real mf;                                  // wave==5 scratch

    analog begin
        t = $abstime;
        // ngspice waveform defaults come from the transient tstep/tstop (vsrcload.c)
        tstep = $simparam("step", 1.0e-9);
        tstop = $simparam("tfinal", 1.0e-3);

        // Waveform value (vsrcload.c — all waveform cases)
        val = dc;

        if (wave == 1) begin
            // SINE(VO VA FREQ TD THETA PHASE) — vsrcload.c SINE case
            freq = (sin_freq != 0.0) ? sin_freq : (1.0 / tstop);
            phase_rad = sin_phase * `M_PI / 180.0;
            tp = t - sin_td;
            if (tp <= 0.0) begin
                val = sin_vo;
            end else begin
                val = sin_vo + sin_va * sin(2.0 * `M_PI * freq * tp + phase_rad) * exp(0.0 - tp * sin_theta);
            end
        end else if (wave == 2) begin
            // PULSE(V1 V2 TD TR TF PW PER) — vsrcload.c PULSE case
            tr  = (pulse_tr  != 0.0) ? pulse_tr  : tstep;
            tf  = (pulse_tf  != 0.0) ? pulse_tf  : tstep;
            pw  = (pulse_pw  != 0.0) ? pulse_pw  : tstop;
            per = (pulse_per != 0.0) ? pulse_per : tstop;
            tp = t - pulse_td;
            if (per > 0.0 && tp > per) begin
                tp = tp - per * floor(tp / per);
            end
            if (tp <= 0.0 || tp >= tr + pw + tf) begin
                val = pulse_v1;
            end else if (tp < tr) begin
                val = pulse_v1 + (pulse_v2 - pulse_v1) * tp / tr;
            end else if (tp <= tr + pw) begin
                val = pulse_v2;
            end else begin
                val = pulse_v2 + (pulse_v1 - pulse_v2) * (tp - tr - pw) / tf;
            end
        end else if (wave == 3) begin
            // EXP(V1 V2 TD1 TAU1 TD2 TAU2) — vsrcload.c EXP case
            td1  = (exp_td1  != 0.0) ? exp_td1  : tstep;
            tau1 = (exp_tau1 != 0.0) ? exp_tau1 : tstep;
            td2  = (exp_td2  != 0.0) ? exp_td2  : (td1 + tstep);
            tau2 = (exp_tau2 != 0.0) ? exp_tau2 : tstep;
            if (t <= td1) begin
                val = exp_v1;
            end else begin
                val = exp_v1 + (exp_v2 - exp_v1) * (1.0 - exp(0.0 - (t - td1) / tau1));
                if (t > td2) begin
                    val = val + (exp_v1 - exp_v2) * (1.0 - exp(0.0 - (t - td2) / tau2));
                end
            end
        end else if (wave == 4) begin
            // SFFM(VO VA FC MDI FS) — vsrcload.c SFFM case
            fc = (sffm_fc != 0.0) ? sffm_fc : (1.0 / tstop);
            fs = (sffm_fs != 0.0) ? sffm_fs : (1.0 / tstop);
            val = sffm_vo + sffm_va * sin(2.0 * `M_PI * fc * t + sffm_mdi * sin(2.0 * `M_PI * fs * t));
        end else if (wave == 5) begin
            // AM(VA VO MF FC TD) — vsrcload.c AM case
            mf = (am_mf != 0.0) ? am_mf : (1.0 / tstop);
            tp = t - am_td;
            if (tp <= 0.0) begin
                val = 0.0;
            end else begin
                val = am_va * (am_vo + sin(2.0 * `M_PI * mf * tp)) * sin(2.0 * `M_PI * am_fc * tp);
            end
        end else if (wave == 6) begin
            // PWL(t0,v0 ... t7,v7) — linear interpolation between the
            // bracketing breakpoints, held flat before the first and
            // after the last.
            if (t <= pwl_t0) begin
                val = pwl_v0;
            end else if (t >= pwl_t7) begin
                val = pwl_v7;
            end else if (t < pwl_t1) begin
                val = pwl_v0 + (pwl_v1 - pwl_v0) * (t - pwl_t0) / (pwl_t1 - pwl_t0);
            end else if (t < pwl_t2) begin
                val = pwl_v1 + (pwl_v2 - pwl_v1) * (t - pwl_t1) / (pwl_t2 - pwl_t1);
            end else if (t < pwl_t3) begin
                val = pwl_v2 + (pwl_v3 - pwl_v2) * (t - pwl_t2) / (pwl_t3 - pwl_t2);
            end else if (t < pwl_t4) begin
                val = pwl_v3 + (pwl_v4 - pwl_v3) * (t - pwl_t3) / (pwl_t4 - pwl_t3);
            end else if (t < pwl_t5) begin
                val = pwl_v4 + (pwl_v5 - pwl_v4) * (t - pwl_t4) / (pwl_t5 - pwl_t4);
            end else if (t < pwl_t6) begin
                val = pwl_v5 + (pwl_v6 - pwl_v5) * (t - pwl_t5) / (pwl_t6 - pwl_t5);
            end else begin
                val = pwl_v6 + (pwl_v7 - pwl_v6) * (t - pwl_t6) / (pwl_t7 - pwl_t6);
            end
        end

        // DC operating point uses the dc value; transient uses the waveform.
        // Both fold into ONE branch contribution alongside the AC stimulus so
        // the source is a single ideal-voltage MNA branch (vsrcload.c): the
        // dc/tran value drives DC/transient, `ac_stim` drives its RHS in AC
        // analysis.
        vval = $analysis("tran") ? val : dc;
        V(p, n) <+ vval + ac_stim(ac_mag, ac_phase);
    end
endmodule

// ════════════════════════════════════════════════════════════════════════════
//  ISRC — current source
// ════════════════════════════════════════════════════════════════════════════

module isrc (inout electrical p, inout electrical n);
    parameter real dc       = 0.0;
    parameter real ac_mag   = 0.0;
    parameter real ac_phase = 0.0;
    parameter real m        = 1.0;        // parallel multiplier
    parameter integer wave  = 0;          // 0=dc, 1=sin, 2=pulse, 3=exp, 4=sffm, 5=am, 6=pwl

    // SIN params (0 sentinels resolve to ngspice defaults)
    parameter real sin_vo    = 0.0;
    parameter real sin_va    = 1.0e-3;
    parameter real sin_freq  = 0.0;
    parameter real sin_td    = 0.0;
    parameter real sin_theta = 0.0;
    parameter real sin_phase = 0.0;

    // PULSE params
    parameter real pulse_v1  = 0.0;
    parameter real pulse_v2  = 1.0e-3;
    parameter real pulse_td  = 0.0;
    parameter real pulse_tr  = 0.0;
    parameter real pulse_tf  = 0.0;
    parameter real pulse_pw  = 0.0;
    parameter real pulse_per = 0.0;

    // EXP params
    parameter real exp_v1   = 0.0;
    parameter real exp_v2   = 1.0e-3;
    parameter real exp_td1  = 0.0;
    parameter real exp_tau1 = 0.0;
    parameter real exp_td2  = 0.0;
    parameter real exp_tau2 = 0.0;

    // SFFM params
    parameter real sffm_vo  = 0.0;
    parameter real sffm_va  = 1.0e-3;
    parameter real sffm_fc  = 0.0;
    parameter real sffm_mdi = 0.0;
    parameter real sffm_fs  = 0.0;

    // AM params
    parameter real am_va = 1.0e-3;
    parameter real am_vo = 0.0;
    parameter real am_mf = 0.0;
    parameter real am_fc = 0.0;
    parameter real am_td = 0.0;

    // PWL — see `vsrc`'s own params for the disclosed 8-point scope note.
    parameter real pwl_t0 = 0.0;
    parameter real pwl_v0 = 0.0;
    parameter real pwl_t1 = 1.0;
    parameter real pwl_v1 = 0.0;
    parameter real pwl_t2 = 2.0;
    parameter real pwl_v2 = 0.0;
    parameter real pwl_t3 = 3.0;
    parameter real pwl_v3 = 0.0;
    parameter real pwl_t4 = 4.0;
    parameter real pwl_v4 = 0.0;
    parameter real pwl_t5 = 5.0;
    parameter real pwl_v5 = 0.0;
    parameter real pwl_t6 = 6.0;
    parameter real pwl_v6 = 0.0;
    parameter real pwl_t7 = 7.0;
    parameter real pwl_v7 = 0.0;

    real t, tstep, tstop, val;
    real tp, phase_rad;
    real freq;
    real tr, tf, pw, per;
    real td1, tau1, td2, tau2;
    real fc, fs;
    real mf;

    analog begin
        t = $abstime;
        tstep = $simparam("step", 1.0e-9);
        tstop = $simparam("tfinal", 1.0e-3);

        val = dc;

        if (wave == 1) begin
            freq = (sin_freq != 0.0) ? sin_freq : (1.0 / tstop);
            phase_rad = sin_phase * `M_PI / 180.0;
            tp = t - sin_td;
            if (tp <= 0.0) begin
                val = sin_vo;
            end else begin
                val = sin_vo + sin_va * sin(2.0 * `M_PI * freq * tp + phase_rad) * exp(0.0 - tp * sin_theta);
            end
        end else if (wave == 2) begin
            tr  = (pulse_tr  != 0.0) ? pulse_tr  : tstep;
            tf  = (pulse_tf  != 0.0) ? pulse_tf  : tstep;
            pw  = (pulse_pw  != 0.0) ? pulse_pw  : tstop;
            per = (pulse_per != 0.0) ? pulse_per : tstop;
            tp = t - pulse_td;
            if (per > 0.0 && tp > per) begin
                tp = tp - per * floor(tp / per);
            end
            if (tp <= 0.0 || tp >= tr + pw + tf) begin
                val = pulse_v1;
            end else if (tp < tr) begin
                val = pulse_v1 + (pulse_v2 - pulse_v1) * tp / tr;
            end else if (tp <= tr + pw) begin
                val = pulse_v2;
            end else begin
                val = pulse_v2 + (pulse_v1 - pulse_v2) * (tp - tr - pw) / tf;
            end
        end else if (wave == 3) begin
            td1  = (exp_td1  != 0.0) ? exp_td1  : tstep;
            tau1 = (exp_tau1 != 0.0) ? exp_tau1 : tstep;
            td2  = (exp_td2  != 0.0) ? exp_td2  : (td1 + tstep);
            tau2 = (exp_tau2 != 0.0) ? exp_tau2 : tstep;
            if (t <= td1) begin
                val = exp_v1;
            end else begin
                val = exp_v1 + (exp_v2 - exp_v1) * (1.0 - exp(0.0 - (t - td1) / tau1));
                if (t > td2) begin
                    val = val + (exp_v1 - exp_v2) * (1.0 - exp(0.0 - (t - td2) / tau2));
                end
            end
        end else if (wave == 4) begin
            fc = (sffm_fc != 0.0) ? sffm_fc : (1.0 / tstop);
            fs = (sffm_fs != 0.0) ? sffm_fs : (1.0 / tstop);
            val = sffm_vo + sffm_va * sin(2.0 * `M_PI * fc * t + sffm_mdi * sin(2.0 * `M_PI * fs * t));
        end else if (wave == 5) begin
            mf = (am_mf != 0.0) ? am_mf : (1.0 / tstop);
            tp = t - am_td;
            if (tp <= 0.0) begin
                val = 0.0;
            end else begin
                val = am_va * (am_vo + sin(2.0 * `M_PI * mf * tp)) * sin(2.0 * `M_PI * am_fc * tp);
            end
        end else if (wave == 6) begin
            if (t <= pwl_t0) begin
                val = pwl_v0;
            end else if (t >= pwl_t7) begin
                val = pwl_v7;
            end else if (t < pwl_t1) begin
                val = pwl_v0 + (pwl_v1 - pwl_v0) * (t - pwl_t0) / (pwl_t1 - pwl_t0);
            end else if (t < pwl_t2) begin
                val = pwl_v1 + (pwl_v2 - pwl_v1) * (t - pwl_t1) / (pwl_t2 - pwl_t1);
            end else if (t < pwl_t3) begin
                val = pwl_v2 + (pwl_v3 - pwl_v2) * (t - pwl_t2) / (pwl_t3 - pwl_t2);
            end else if (t < pwl_t4) begin
                val = pwl_v3 + (pwl_v4 - pwl_v3) * (t - pwl_t3) / (pwl_t4 - pwl_t3);
            end else if (t < pwl_t5) begin
                val = pwl_v4 + (pwl_v5 - pwl_v4) * (t - pwl_t4) / (pwl_t5 - pwl_t4);
            end else if (t < pwl_t6) begin
                val = pwl_v5 + (pwl_v6 - pwl_v5) * (t - pwl_t5) / (pwl_t6 - pwl_t5);
            end else begin
                val = pwl_v6 + (pwl_v7 - pwl_v6) * (t - pwl_t6) / (pwl_t7 - pwl_t6);
            end
        end

        // Current injection (isrcload.c: RHS[p] += m*value, RHS[n] -= m*value).
        // The DC value scales with the source-stepping ramp (ngspice cktop.c:
        // CKTsrcFact multiplies every independent source); 1.0 outside the
        // homotopy, so normal operation is untouched.
        if ($analysis("tran")) begin
            I(p, n) <+ m * val;
        end else begin
            I(p, n) <+ m * dc * $simparam("sourceScaleFactor", 1.0);
        end

        // AC stimulus
        I(p, n) <+ m * ac_stim(ac_mag, ac_phase);
    end
endmodule
