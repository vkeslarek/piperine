// NGSPICE faithful models — package aggregator.
//
// Migrated from `lib.phdl` (T43, VAMS-08). PHDL's package-import mechanism
// (`use spice::constants;` etc.) pulled in every model file by name; VAMS
// has no package/`use` concept (LRM ch. 10 preprocessing is pure textual
// inclusion), so the equivalent is `` `include`` on each model file in the
// same order the original listed them. Nothing in this tree consumes
// `lib.phdl`/`lib.va` today (grep-confirmed before this migration) — it is
// a standalone convenience header for a project that wants the whole
// `spice` package with one `` `include``.
//
// The original `lib.phdl` never listed `urc` (its own `use` list omits
// `use spice::urc;`) — preserved as-authored here, not silently extended.

`ifdef SPICE_LIB_VA
`else
`define SPICE_LIB_VA 1

`include "constants.va"
`include "diode.va"
`include "bjt.va"
`include "jfet.va"
`include "mos.va"
`include "passives.va"
`include "sources.va"
`include "switches.va"
`include "controlled.va"
`include "tline.va"

`endif
