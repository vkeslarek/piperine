// NGSPICE faithful models — transmission lines.
//
// Source: ngspice/src/spicelib/devices/tra/  (lossless line, Branin method)
//
// The ideal lossless line uses Branin's traveling-wave companion: each port
// is a Thevenin equivalent — a series resistor Z0 to an internal node, with a
// voltage source (internal node -> return) carrying the delayed wave that left
// the far port one transit time (td) ago. The `absdelay` runtime operator
// (LRM Sec 4.5) supplies the retarded quantity — PHDL's predecessor spelled
// this `delay(x, td)`, a name that resolves to the exact same codegen
// operator (`resolve/pom/analog_ops.rs` registers both `"delay"` and
// `"absdelay"` onto one `Delay` op), but `absdelay` is the name LRM Annex B
// actually reserves, so the real-Verilog-A form is used here (T43, VAMS-08).
//
// Derivation (lossless line, forward wave f: port1->port2, backward g):
//   v1 = f(t)   + g(t),      Z0.i1 = f(t)   - g(t)     [i = current INTO line]
//   v2 = f(t-td)+ g(t+td),   Z0.i2 = g(t+td)- f(t-td)
//   => v1(t) = Z0.i1(t) + Es1,   Es1 = [ v2 + Z0.i2 ](t-td)
//      v2(t) = Z0.i2(t) + Es2,   Es2 = [ v1 + Z0.i1 ](t-td)
//
// The wave leaving a port, v + Z0.i, is expressed with the internal source
// node k: since v(p,n) = Z0.i + v(k,n) (resistor Z0 from p to k, source k->n),
// the current i = (v(p)-v(k))/Z0, so  v + Z0.i = 2.v(p,n) - v(k,n) — a pure
// node-voltage combination the delay operator can sample without reading any
// branch current.
//
// Migrated from `tline.phdl` (T43, VAMS-08) — a dialect rewrite, values and
// equations unchanged. PHDL's `$assert(z0 > 0.0, ...)`/`$assert(td > 0.0,
// ...)` become `from` range constraints on the parameter declarations (the
// idiom `passives.va`'s `xfmr` module already established at T41 — a
// declaration-site LRM Sec 3.4.2 range check rather than a runtime
// `$assert`, VAMS has no such task). PHDL's `dest <- src` (`BindOp::Force`,
// T32's documented SPEC_DEVIATION) becomes `<+` — both `<-` sites here
// (the Thevenin sources `V(k1,n1)`/`V(k2,n2)`) are each the ONLY
// contribution to their own implicit branch (distinct from the
// `I(p1,k1)`/`I(p2,k2)` series-resistor branches), so the substitution is
// exact — no LRM Sec 5.4.2 potential/flow conflict (unlike `passives.va`'s
// `cap`/`ind` UIC case).
// ════════════════════════════════════════════════════════════════════════════

`include "disciplines.vams"

// ════════════════════════════════════════════════════════════════════════════
//  tline — ideal lossless transmission line  (T element, Branin companion)
//
//  Two ports (p1,n1) and (p2,n2); z0 = characteristic impedance, td = one-way
//  transit delay. Each port branch is a resistor z0 in series with the delayed
//  far-end wave.
// ════════════════════════════════════════════════════════════════════════════

module tline (inout electrical p1, inout electrical n1, inout electrical p2, inout electrical n2);
    // See `passives.va`'s `xfmr` comment for why an upper bound is given at
    // all (this codegen's elaboration-constant evaluator does not resolve
    // an unbounded `inf` literal yet) — 1e15 is a stand-in "large enough"
    // ceiling, not a physically meaningful one.
    parameter real z0 = 50.0    from (0:1e15);   // characteristic impedance (Ohm)
    parameter real td = 1.0e-9  from (0:1e15);   // one-way transit delay (s)

    electrical k1;   // port-1 internal source node
    electrical k2;   // port-2 internal source node

    real wave1, wave2;

    analog begin
        // Series resistor Z0 from each external port to its internal source node.
        I(p1, k1) <+ V(p1, k1) / z0;
        I(p2, k2) <+ V(p2, k2) / z0;

        // Wave leaving each port = 2.v(port) - v(internal) = v + Z0.i (node-only).
        wave1 = 2.0 * V(p1, n1) - V(k1, n1);
        wave2 = 2.0 * V(p2, n2) - V(k2, n2);

        // The Thevenin source at each port carries the far port's wave,
        // retarded by one transit time.
        V(k1, n1) <+ absdelay(wave2, td);
        V(k2, n2) <+ absdelay(wave1, td);
    end
endmodule
