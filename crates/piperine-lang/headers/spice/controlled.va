// NGSPICE faithful models — controlled sources.
//
// Source: ngspice/src/spicelib/devices/{vcvs,vccs,ccvs,cccs}/
//   vcvsdefs.h  vcvsload.c  vcvsparam.c
//   vccsdefs.h  vccsload.c  vccsparam.c
//   ccvsdefs.h  ccvsload.c  ccvsparam.c
//   cccsdefs.h  cccsload.c  cccsparam.c
//
// VCVS (E) — V(out) = gain . V(ctrl)         — voltage-controlled voltage source
// VCCS (G) — I(out) = trans . V(ctrl)        — voltage-controlled current source
// CCVS (H) — V(out) = trans . I(ctrl)        — current-controlled voltage source
// CCCS (F) — I(out) = gain . I(ctrl)         — current-controlled current source
//
// For CCVS/CCCS, the controlling current is sensed via I(cp, cn) — in SPICE
// this is the branch current of a 0 V vsrc connected between cp and cn.
//
// All formulas translated from the respective *load.c files — mechanical
// dialect rewrite of the PHDL predecessor this file replaces (T41,
// VAMS-08), values/equations unchanged. PHDL's `dest <- src`
// (`BindOp::Force`, VCVS/CCVS) has no VAMS Annex A production (T32's
// documented SPEC_DEVIATION); both uses here are unconditional single
// contributions to their own branch (no other contribution shares `p,n`),
// so `<+` is an exact semantic match, not an approximation.
//
// KNOWN CODEGEN GAPS (found during T41, not caused by this translation —
// both `ccvs` and `cccs` parse/elaborate cleanly, confirmed independently
// of any particular phrasing, see `switches.va`'s header for the same
// finding on `csw`):
//   - `cccs`: `AnalogKernel::compile` rejects it with the same
//     `disto2: ... current-controlled nonlinearities have no voltage-pair
//     higher derivative` `Unsupported` this file's `switches.va` sibling
//     documents for `csw` — reading a controlling branch current via
//     `I(...)` trips it unconditionally.
//   - `ccvs`: fails differently — `Unsupported("branch-current term in a
//     potential force must probe a forced branch (\`V(...) <+ ...\`)")`,
//     i.e. a `V(p,n) <+ ... I(cp,cn) ...` contribution requires `cp,cn`
//     itself to carry a Potential contribution, which a controlling branch
//     (normally the branch of an external 0 V sensing `vsrc`) never does.
// Both are inherent to what a current-controlled voltage/current source
// physically is (LRM's own H/F-element analogue), not an artifact of this
// dialect rewrite — `vcvs`/`vccs` (voltage-controlled, reading `V(...)`
// instead) compile end-to-end with no issue. Flagged for codegen follow-up.
// ════════════════════════════════════════════════════════════════════════════

`include "disciplines.vams"

// ════════════════════════════════════════════════════════════════════════════
//  VCVS — Voltage-Controlled Voltage Source  (E element, vcvsload.c)
//  V(p,n) = gain . (V(cp) - V(cn))
//  Creates an internal branch-current unknown (like a vsrc).
// ════════════════════════════════════════════════════════════════════════════

module vcvs (
    inout electrical p,
    inout electrical n,
    inout electrical cp,
    inout electrical cn
);
    parameter real gain = 1.0;

    analog begin
        V(p, n) <+ gain * V(cp, cn);
    end
endmodule

// ════════════════════════════════════════════════════════════════════════════
//  VCCS — Voltage-Controlled Current Source  (G element, vccsload.c)
//  I(p,n) = m . trans . (V(cp) - V(cn))
//  No internal node — pure current injection.
// ════════════════════════════════════════════════════════════════════════════

module vccs (
    inout electrical p,
    inout electrical n,
    inout electrical cp,
    inout electrical cn
);
    parameter real trans = 1.0;
    parameter real m     = 1.0;

    analog begin
        I(p, n) <+ m * trans * V(cp, cn);
    end
endmodule

// ════════════════════════════════════════════════════════════════════════════
//  CCVS — Current-Controlled Voltage Source  (H element, ccvsload.c)
//  V(p,n) = trans . I(cp,cn)
//  I(cp,cn) is the current through the controlling branch (a 0 V vsrc).
//  Creates an internal branch-current unknown for the output.
// ════════════════════════════════════════════════════════════════════════════

module ccvs (
    inout electrical p,
    inout electrical n,
    inout electrical cp,
    inout electrical cn
);
    parameter real trans = 1.0;

    analog begin
        V(p, n) <+ trans * I(cp, cn);
    end
endmodule

// ════════════════════════════════════════════════════════════════════════════
//  CCCS — Current-Controlled Current Source  (F element, cccsload.c)
//  I(p,n) = m . gain . I(cp,cn)
//  I(cp,cn) is the current through the controlling branch (a 0 V vsrc).
//  No internal node — pure current injection.
// ════════════════════════════════════════════════════════════════════════════

module cccs (
    inout electrical p,
    inout electrical n,
    inout electrical cp,
    inout electrical cn
);
    parameter real gain = 1.0;
    parameter real m    = 1.0;

    analog begin
        I(p, n) <+ m * gain * I(cp, cn);
    end
endmodule
