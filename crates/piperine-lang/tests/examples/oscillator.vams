// oscillator.vams — LC tank + ring oscillator, migrated from PHDL.
//
// MD-45 NOTES:
//  - The PHDL `@ initial { V(p, n) = 1.0; }` used Force (`<-`), which is
//    deleted. The closest VAMS form, `@(initial_step) V(p, n) <+ 1.0;`,
//    conflicts with the unconditional Flow contribution on the same branch
//    (LRM §5.4.2) — same gap NGP-10 already documents for `cap`/`ind` IC.
//    The init is dropped here (documented, not silently).
//  - `RingOsc[N]` used PHDL's compile-time generic-module monomorphization.
//    VAMS has no module generics — the chain is written concretely (N=3).
`include "disciplines.vams"

module LcTank (inout electrical p, inout electrical n);
    parameter real l = 1.0e-6;
    parameter real c = 1.0e-9;
    analog begin
        I(p, n) <+ c * ddt(V(p, n)) + idt(V(p, n)) / l;
    end
endmodule

module Inverter (input electrical a, inout electrical y, inout electrical gnd);
    parameter real gain = 10.0;
    parameter real c = 1.0e-15;
    parameter real r = 1.0e3;
    real v_target;
    analog begin
        v_target = -gain * V(a, gnd);
        I(y, gnd) <+ c * ddt(V(y, gnd)) + (V(y, gnd) - v_target) / r;
    end
endmodule

// Concrete N=3 ring (VAMS has no module generics).
module RingOsc (inout electrical gnd);
    electrical n0, n1, n2;
    Inverter i0 (.a(n2), .y(n0), .gnd(gnd));
    Inverter i1 (.a(n0), .y(n1), .gnd(gnd));
    Inverter i2 (.a(n1), .y(n2), .gnd(gnd));
endmodule
