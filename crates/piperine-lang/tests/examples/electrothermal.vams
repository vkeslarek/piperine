// electrothermal.vams — electrothermal resistor demo, migrated from PHDL.
// Uses the stdlib `thermal` discipline (potential=Temperature/access=Temp,
// flow=Power/access=Pwr) declared in `disciplines.vams`.
`include "disciplines.vams"

module HeatedResistor (inout electrical p, inout electrical n, inout thermal th);
    parameter real r0 = 1.0e3;
    parameter real t0 = 300.0;
    parameter real tc = 0.004;
    analog begin
        I(p, n) <+ V(p, n) / (r0 * (1.0 + tc * (Temp(th) - t0)));
        Pwr(th) <+ V(p, n) * V(p, n) / (r0 * (1.0 + tc * (Temp(th) - t0)));
    end
endmodule
