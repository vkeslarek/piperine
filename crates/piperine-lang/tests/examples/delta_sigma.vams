// delta_sigma.vams — first-order delta-sigma modulator, migrated from PHDL.
//
// MD-45 NOTE: the PHDL file used `var q : Bit = 0;` and `var vfb : Real = ...`
// with PHDL's local-var initializer syntax. VAMS's `VarDecl` has no
// initializer, so `q` starts at the digital kernel's X sentinel; `vfb`
// mirrors `q` each analog step so its init doesn't matter. The .rs test
// that consumed this fixture (`tests/parse_elab.rs`) is in T21's documented
// compile-failure inventory anyway.
`include "disciplines.vams"

module DeltaSigma (input electrical vin, inout electrical gnd, input logic clk, output logic dout);
    parameter real c = 1.0e-12;
    parameter real r = 1.0e3;
    parameter real vref = 1.0;
    electrical intg;
    reg q;
    real vfb;
    analog begin
        vfb = (q == 1) ? vref : -vref;
        I(intg, gnd) <+ c * ddt(V(intg, gnd));
        I(intg, gnd) <+ (vfb - V(vin)) / r;
    end
    always @(posedge clk) q <= (V(intg) > 0.0);
    always @(*) dout <= q;
endmodule
