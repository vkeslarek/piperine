// op_amp.vams — single-pole op-amp macromodel, migrated from the PHDL
// predecessor. The PHDL file used the deleted `<-` Force operator for the
// ideal output buffer; VAMS's `<+` is the direct replacement (T32's
// documented SPEC_DEVIATION — Force was never semantically distinct for
// unconditional potential contributions).
`include "disciplines.vams"

module OpAmp (input electrical inp, input electrical inn, inout electrical out);
    parameter real gain = 1.0e6;
    analog begin
        V(out) <+ gain * V(inp, inn);
    end
endmodule
