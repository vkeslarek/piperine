// accumulator.vams — formerly demonstrated Piperine's generic + capability
// surface: `mod Accumulator[W] (input clk : Bit, input en : Bit, input x :
// UInt[W], output sum : UInt[W])` with `var acc : UInt[W] = 0;` and
// `acc = acc + x;` dispatching through `UInt`'s `Add` capability impl.
//
// MD-45 (2026-08-13): VAMS Annex A has no module generics, no UInt
// abstract type, no capability dispatch. The Accumulator is rewritten
// here concretely (W=8) as a plain 1364-style `reg [7:0]` accumulator
// with an `always @(posedge clk)` body — the same observable behavior
// the deleted `impl Add for UInt[8]` produced, just without the
// polymorphic indirection. The original PHDL file's `+` operator
// resolution through `UInt::add` is gone; the 1364 `+` operator on
// `reg [W-1:0]` is the VAMS-native equivalent.
`include "disciplines.vams"

module Accumulator (input logic clk, input logic en,
                    input logic [7:0] x, output logic [7:0] sum);
    reg [7:0] acc;
    always @(posedge clk) begin
        if (en == 1) acc <= acc + x;
    end
    always @(*) sum <= acc;
endmodule
