* power_stage: the analog power stage of the buck (ideal supply, two ideal switches driven by
* piecewise-linear controls, inductor, capacitor, load), the twin of power_stage.msl. The
* switches are hard (`vh=0`), closed at 10 mOhm above half a volt and open at 10 MOhm below. The
* controls are 50 periods of 2 us: 200 ns high with 10 ns edges, the complement with 10 ns of
* dead time. TMAX is the 10 ns the piperine run caps its step at. Not a parity twin: it is read by
* `power_stage_bench.rs`, which prints the accepted steps and the time per step of both.
Vin vin 0 DC 12
Vc ctl 0 PWL(0 0 1e-08 1 2e-07 1 2.1e-07 0 2e-06 0 2.01e-06 1 2.2e-06 1 2.21e-06 0 4e-06 0 4.01e-06 1 4.2e-06 1 4.21e-06 0 6e-06 0 6.01e-06 1 6.2e-06 1 6.21e-06 0 8e-06 0 8.01e-06 1 8.2e-06 1 8.21e-06 0 1e-05 0 1.001e-05 1 1.02e-05 1 1.021e-05 0 1.2e-05 0 1.201e-05 1 1.22e-05 1 1.221e-05 0 1.4e-05 0 1.401e-05 1 1.42e-05 1 1.421e-05 0 1.6e-05 0 1.601e-05 1 1.62e-05 1 1.621e-05 0 1.8e-05 0 1.801e-05 1 1.82e-05 1 1.821e-05 0 2e-05 0 2.001e-05 1 2.02e-05 1 2.021e-05 0 2.2e-05 0 2.201e-05 1 2.22e-05 1 2.221e-05 0 2.4e-05 0 2.401e-05 1 2.42e-05 1 2.421e-05 0 2.6e-05 0 2.601e-05 1 2.62e-05 1 2.621e-05 0 2.8e-05 0 2.801e-05 1 2.82e-05 1 2.821e-05 0 3e-05 0 3.001e-05 1 3.02e-05 1 3.021e-05 0 3.2e-05 0 3.201e-05 1 3.22e-05 1 3.221e-05 0 3.4e-05 0 3.401e-05 1 3.42e-05 1 3.421e-05 0 3.6e-05 0 3.601e-05 1 3.62e-05 1 3.621e-05 0 3.8e-05 0 3.801e-05 1 3.82e-05 1 3.821e-05 0 4e-05 0 4.001e-05 1 4.02e-05 1 4.021e-05 0 4.2e-05 0 4.201e-05 1 4.22e-05 1 4.221e-05 0 4.4e-05 0 4.401e-05 1 4.42e-05 1 4.421e-05 0 4.6e-05 0 4.601e-05 1 4.62e-05 1 4.621e-05 0 4.8e-05 0 4.801e-05 1 4.82e-05 1 4.821e-05 0 5e-05 0 5.001e-05 1 5.02e-05 1 5.021e-05 0 5.2e-05 0 5.201e-05 1 5.22e-05 1 5.221e-05 0 5.4e-05 0 5.401e-05 1 5.42e-05 1 5.421e-05 0 5.6e-05 0 5.601e-05 1 5.62e-05 1 5.621e-05 0 5.8e-05 0 5.801e-05 1 5.82e-05 1 5.821e-05 0 6e-05 0 6.001e-05 1 6.02e-05 1 6.021e-05 0 6.2e-05 0 6.201e-05 1 6.22e-05 1 6.221e-05 0 6.4e-05 0 6.401e-05 1 6.42e-05 1 6.421e-05 0 6.6e-05 0 6.601e-05 1 6.62e-05 1 6.621e-05 0 6.8e-05 0 6.801e-05 1 6.82e-05 1 6.821e-05 0 7e-05 0 7.001e-05 1 7.02e-05 1 7.021e-05 0 7.2e-05 0 7.201e-05 1 7.22e-05 1 7.221e-05 0 7.4e-05 0 7.401e-05 1 7.42e-05 1 7.421e-05 0 7.6e-05 0 7.601e-05 1 7.62e-05 1 7.621e-05 0 7.8e-05 0 7.801e-05 1 7.82e-05 1 7.821e-05 0 8e-05 0 8.001e-05 1 8.02e-05 1 8.021e-05 0 8.2e-05 0 8.201e-05 1 8.22e-05 1 8.221e-05 0 8.4e-05 0 8.401e-05 1 8.42e-05 1 8.421e-05 0 8.6e-05 0 8.601e-05 1 8.62e-05 1 8.621e-05 0 8.8e-05 0 8.801e-05 1 8.82e-05 1 8.821e-05 0 9e-05 0 9.001e-05 1 9.02e-05 1 9.021e-05 0 9.2e-05 0 9.201e-05 1 9.22e-05 1 9.221e-05 0 9.4e-05 0 9.401e-05 1 9.42e-05 1 9.421e-05 0 9.6e-05 0 9.601e-05 1 9.62e-05 1 9.621e-05 0 9.8e-05 0 9.801e-05 1 9.82e-05 1 9.821e-05 0 0.0001 0)
Vcb ctlb 0 PWL(0 1 1e-08 0 2.2e-07 0 2.3e-07 1 2e-06 1 2.01e-06 0 2.22e-06 0 2.23e-06 1 4e-06 1 4.01e-06 0 4.22e-06 0 4.23e-06 1 6e-06 1 6.01e-06 0 6.22e-06 0 6.23e-06 1 8e-06 1 8.01e-06 0 8.22e-06 0 8.23e-06 1 1e-05 1 1.001e-05 0 1.022e-05 0 1.023e-05 1 1.2e-05 1 1.201e-05 0 1.222e-05 0 1.223e-05 1 1.4e-05 1 1.401e-05 0 1.422e-05 0 1.423e-05 1 1.6e-05 1 1.601e-05 0 1.622e-05 0 1.623e-05 1 1.8e-05 1 1.801e-05 0 1.822e-05 0 1.823e-05 1 2e-05 1 2.001e-05 0 2.022e-05 0 2.023e-05 1 2.2e-05 1 2.201e-05 0 2.222e-05 0 2.223e-05 1 2.4e-05 1 2.401e-05 0 2.422e-05 0 2.423e-05 1 2.6e-05 1 2.601e-05 0 2.622e-05 0 2.623e-05 1 2.8e-05 1 2.801e-05 0 2.822e-05 0 2.823e-05 1 3e-05 1 3.001e-05 0 3.022e-05 0 3.023e-05 1 3.2e-05 1 3.201e-05 0 3.222e-05 0 3.223e-05 1 3.4e-05 1 3.401e-05 0 3.422e-05 0 3.423e-05 1 3.6e-05 1 3.601e-05 0 3.622e-05 0 3.623e-05 1 3.8e-05 1 3.801e-05 0 3.822e-05 0 3.823e-05 1 4e-05 1 4.001e-05 0 4.022e-05 0 4.023e-05 1 4.2e-05 1 4.201e-05 0 4.222e-05 0 4.223e-05 1 4.4e-05 1 4.401e-05 0 4.422e-05 0 4.423e-05 1 4.6e-05 1 4.601e-05 0 4.622e-05 0 4.623e-05 1 4.8e-05 1 4.801e-05 0 4.822e-05 0 4.823e-05 1 5e-05 1 5.001e-05 0 5.022e-05 0 5.023e-05 1 5.2e-05 1 5.201e-05 0 5.222e-05 0 5.223e-05 1 5.4e-05 1 5.401e-05 0 5.422e-05 0 5.423e-05 1 5.6e-05 1 5.601e-05 0 5.622e-05 0 5.623e-05 1 5.8e-05 1 5.801e-05 0 5.822e-05 0 5.823e-05 1 6e-05 1 6.001e-05 0 6.022e-05 0 6.023e-05 1 6.2e-05 1 6.201e-05 0 6.222e-05 0 6.223e-05 1 6.4e-05 1 6.401e-05 0 6.422e-05 0 6.423e-05 1 6.6e-05 1 6.601e-05 0 6.622e-05 0 6.623e-05 1 6.8e-05 1 6.801e-05 0 6.822e-05 0 6.823e-05 1 7e-05 1 7.001e-05 0 7.022e-05 0 7.023e-05 1 7.2e-05 1 7.201e-05 0 7.222e-05 0 7.223e-05 1 7.4e-05 1 7.401e-05 0 7.422e-05 0 7.423e-05 1 7.6e-05 1 7.601e-05 0 7.622e-05 0 7.623e-05 1 7.8e-05 1 7.801e-05 0 7.822e-05 0 7.823e-05 1 8e-05 1 8.001e-05 0 8.022e-05 0 8.023e-05 1 8.2e-05 1 8.201e-05 0 8.222e-05 0 8.223e-05 1 8.4e-05 1 8.401e-05 0 8.422e-05 0 8.423e-05 1 8.6e-05 1 8.601e-05 0 8.622e-05 0 8.623e-05 1 8.8e-05 1 8.801e-05 0 8.822e-05 0 8.823e-05 1 9e-05 1 9.001e-05 0 9.022e-05 0 9.023e-05 1 9.2e-05 1 9.201e-05 0 9.222e-05 0 9.223e-05 1 9.4e-05 1 9.401e-05 0 9.422e-05 0 9.423e-05 1 9.6e-05 1 9.601e-05 0 9.622e-05 0 9.623e-05 1 9.8e-05 1 9.801e-05 0 9.822e-05 0 9.823e-05 1 0.0001 1)
S1 vin sw ctl 0 SW
S2 sw 0 ctlb 0 SW
.model SW SW(vt=0.5 vh=0 ron=10m roff=10meg)
L1 sw vo 2.2u
C1 vo 0 22u
R1 vo 0 1
.control
tran 0.1u 100u 0 10n uic
rusage
.endc
.end
