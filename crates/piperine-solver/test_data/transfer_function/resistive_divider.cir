Resistive Voltage Divider - Transfer Function Test
* Piperine validation circuit
* Expected: Gain=0.5, R_in=2kΩ, R_out=500Ω

V1 n_in 0 DC 1
R1 n_in n_out 1k
R2 n_out 0 1k

.tf v(n_out) V1
.end
