`include "constants.vams"
`include "disciplines.vams"

// Current source: injects idc from p to n.
module isource_va(inout electrical p, inout electrical n);

    (*desc="DC current", units="A"*)
    parameter real idc = 1.0e-3;

    branch (p, n) br;

    analog begin
        I(br) <+ idc;
    end
endmodule
