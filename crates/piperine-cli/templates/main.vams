// Piperine Verilog-AMS Mixed-Signal Hello World!
//
// This module bridges the continuous (analog) and discrete (digital)
// domains in both directions.
`include "disciplines.vams"

module MixedSignalHelloWorld (
    inout electrical analog_p,
    inout electrical analog_n,
    input logic digital_in,
    output logic digital_out
);
    // Parameters for our mixed-signal thresholds
    parameter real threshold = 1.65;
    parameter real vhigh = 3.3;
    parameter real vlow = 0.0;

    // 1. Digital to Analog (DAC): drive the differential analog voltage
    // based on the digital_in bit.
    analog begin
        V(analog_p, analog_n) <+ (digital_in == 1) ? vhigh : vlow;
    end

    // 2. Analog to Digital (ADC / comparator): continuously read the
    // analog voltage and output a bit if it exceeds the threshold.
    always @(*) begin
        digital_out = V(analog_p, analog_n) > threshold;
    end
endmodule
