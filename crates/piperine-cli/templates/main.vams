`include "disciplines.vams"

/// A simple DC voltage source example
module main(p, n);
    inout p, n;
    electrical p, n;

    parameter real dc_voltage = 5.0;

    analog begin
        // Drives a constant DC voltage across the terminals
        V(p, n) <+ dc_voltage;
    end
endmodule
