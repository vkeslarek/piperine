// Warn on Breakdown
//
// Version 1a, 1 June 04
//
// Ken Kundert
//
// Downloaded from The Designer's Guide Community (www.designers-guide.org).
// Post any questions on www.designers-guide.org/Forum.
// Taken from "The Designer's Guide to Verilog-AMS" by Kundert & Zinke.
// Chapter 5, Listing 5.
//
// This version of the ADC was modified to work in the existing
// version of Spectre (5.0 May 2003).

`include "disciplines.vams"

module breakdown(n);
    input n;
    voltage n;
    parameter real threshold = 1000.0;
    integer given;

    analog begin
        @(above(V(n) - threshold)) begin
            if (!given) begin
                $strobe("Warning: breakdown voltage exceeded (detected by %m at %gs)\n.", $abstime);
                given = 1;
            end
        end
    end
endmodule
