// A simple motor model
//
// Version 1a, 1 June 04
//
// Ken Kundert
//
// Downloaded from The Designer's Guide Community (www.designers-guide.org).
// Post any questions on www.designers-guide.org/Forum.
// Taken from "The Designer's Guide to Verilog-AMS" by Kundert & Zinke.
// Chapter 3, Listing 9.
//
// This version complies with the Verilog-AMS (vers. 2.1) but does not
// run in the existing version of Spectre (5.0 May 03). See smpl_ckt2.vams
// for an alternate version that does run in Spectre.

`include "disciplines.vams"
`include "vsrc.vams"

// A motor test circuit

module test;
    ground gnd;

    vsrc # (.dc(1)) V1(drive, gnd);
    motor M1(drive, gnd, shaft);
endmodule

// Motor

module motor(p, n, shaft);
    parameter real km = 4.5;
    // motor constant (V-s/rad)
    parameter real kf = 6.2;
    // flux constant (N-m/A)
    parameter real j = 0.004;
    // inertia of shaft (N-m-s2/rad)
    parameter real d = 0.1;
    // drag (friction) (N-m-s/rad)
    parameter real r = 5.0;
    // motor winding resistance (Ohms)
    parameter real l = 0.02;
    // motor winding inductance (H)
    inout p, n, shaft;
    electrical p, n;
    rotational_omega shaft;

    analog begin
        V(p, n) <+ km * Omega(shaft) + r * I(p, n) + l * ddt(I(p, n));
        Tau(shaft) <+ kf * I(p, n) - d * Omega(shaft) - j * ddt(Omega(shaft));
    end
endmodule
