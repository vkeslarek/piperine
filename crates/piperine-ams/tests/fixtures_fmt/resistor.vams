// Linear resistor
//
// Uses the resistance formulation (V = IR).
// Best for small valued resistors, resistance may be zero.
//
// Version 1a, 1 June 04
//
// Ken Kundert
//
// Downloaded from The Designer's Guide Community (www.designers-guide.org).
// Post any questions on www.designers-guide.org/Forum.
// Taken from "The Designer's Guide to Verilog-AMS" by Kundert & Zinke.
// Chapter 3, Listing 1.

`include "disciplines.vams"

module resistor(p, n);
    parameter real r = 0;
    // resistance (Ohms)
    inout p, n;
    electrical p, n;

    analog V(p, n) <+ r * I(p, n);
endmodule
