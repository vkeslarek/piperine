// r2_et_cmc version 1.0.1

/*
Copyright (c) 2020 Silicon Integration Initiative, Inc.

Licensed under Educational Community License, Version 2.0 (the "License");
you may not use this file except in compliance with the License. You may
obtain a copy of the license at
http://opensource.org/licenses/ECL-2.0

Unless required by applicable law or agreed to in writing, software distributed
under the License is distributed on an "AS IS" BASIS, WITHOUT WARRANTIES OR
CONDITIONS OF ANY KIND, either express or implied. See the License for the
specific language governing permissions and limitations under the License.

The R2_CMC standard has been developed by the Silicon Integration Initiative's Compact Model Coalition.

CMC Release Date: May 15, 2020
Public Release Date: November 15, 2021

A link to the most recent version of this standard can be found at:
http://www.si2.org/cmc
*/

//
//  This file is the top-level declaration for r2_et_cmc, the CMC 2-terminal resistor model with self-heating
//

`include "r2_cmc_macros.include"

`define electroThermal

module r2_et_cmc(n1, n2, dt);

    `include "r2_cmc_body.include"

endmodule
