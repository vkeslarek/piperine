// Non-Ideal relay
//
// Version 1a, 1 June 04
//
// Ken Kundert
//
// Downloaded from The Designer's Guide Community (www.designers-guide.org).
// Post any questions on www.designers-guide.org/Forum.
// Taken from "The Designer's Guide to Verilog-AMS" by Kundert & Zinke.
// Chapter 3, Listing 18.

`include "disciplines.vams"

module relay(p, n, ps, ns);
    parameter real thresh = 0;
    // threshold (V)
    parameter real ron = 0 from [ 0 : inf);
    // on resistance (Ohms)
    parameter real goff = 0 from [ 0 : 1 / (ron + 1));
    // off conductance (Siemens)
    input ps, ns;
    electrical p, n, ps, ns;

    analog begin
        @(cross(V(ps, ns) - thresh, 0));
        if (V(ps, ns) > thresh) V(p, n) <+ ron * I(p, n);
        else I(p, n) <+ goff * V(p, n);
    end
endmodule
