// Linear inductor
//
// Version 1a, 1 June 04
//
// Ken Kundert
//
// Downloaded from The Designer's Guide Community (www.designers-guide.org).
// Post any questions on www.designers-guide.org/Forum.
// Taken from "The Designer's Guide to Verilog-AMS" by Kundert & Zinke.
// Chapter 3, Listing 4.

`include "disciplines.vams"

module inductor(p, n);
    parameter real l = 0;
    // inductance (H)
    inout p, n;
    electrical p, n;

    analog V(p, n) <+ l * ddt(I(p, n));
endmodule
