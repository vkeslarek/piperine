// Enhanced Bidirectional Connect Module
//
// Version 1a, 1 June 04
//
// Olaf Zinke
//
// Downloaded from The Designer's Guide Community (www.designers-guide.org).
// Post any questions on www.designers-guide.org/Forum.
// Taken from "The Designer's Guide to Verilog-AMS" by Kundert & Zinke.
// Chapter 4, Listing 20.

`include "disciplines.vams"
`timescale 1ns / 10ps

connectmodule bidir(a, d);
    parameter real v0 = 0.0;
    // output voltage for a logic 0 (V)
    parameter real v1 = 5.0;
    // output voltage for a logic 1 (V)
    parameter real ruon = 1k from(0 : inf);
    // pull-up resistance when 1 or x (W)
    parameter real ruoff = 1M from(0 : inf);
    // pull-up resistance when 0 or z (W)
    parameter real rdon = 1k from(0 : inf);
    // pull-down resistance when 1 or x (W)
    parameter real rdoff = 1M from(0 : inf);
    // pull-down resistance when 0 or z (W)
    parameter real tr = 1n from [ 0 : inf);
    // rise time (s)
    parameter real tf = 1n from [ 0 : inf);
    // fall time (s)
    parameter real vl = 0.5;
    // maximum voltage of a logic 0 (V)
    parameter real vh = 2.7;
    // minimum voltage of a logic 1 (V)
    parameter real maxzi = 0.1u;
    // absolute max current allowed in HiZ state
    parameter real xdelay = 1;
    // time in the Xrange before dout gets x
    parameter real zdelay = 0.5 * xdelay;
    // max time of current > maxzi before
    // going out of z state
    inout a, d;
    electrical a;
    logic d;
    parameter real guon = 1.0 / ruon;
    // these are local constants
    parameter real guoff = 1.0 / ruoff;
    // they should not be overridden by the user
    parameter real gdon = 1.0 / rdon;
    parameter real gdoff = 1.0 / rdoff;
    real v, r, gu, gd;
    integer vstate;
    reg istate, inXrange, outOfZcurrent;
    integer DrCount, i;
    integer XCount, ZCount, LCount, HCount;
    reg dout;
    logic dout;
    assign d = dout;

    initial begin
        dout = 1'bz;
        // set the digital output to z until analog voltage is resolved
        vstate = 2;
        istate = 0;
        inXrange = 0;
        outOfZcurrent = 0;
        DrCount = $driver_count(d);
        XCount = 0;
        ZCount = 0;
        LCount = 0;
        HCount = 0;
        for (i = 0;  i < DrCount;  i = i + 1) case
            ($driver_state(d, i)) 1'b0 : LCount = LCount + 1;
            1'b1 : HCount = HCount + 1;
            1'bx : begin
                XCount = XCount + 1;
                dout = 1'bx;
            end
            1'bz : ZCount = ZCount + 1;
        endcase
        gu = (XCount + HCount) * guon + (ZCount + LCount) * guoff;
        gd = (XCount + LCount) * gdon + (ZCount + HCount) * gdoff;
        r = 1.0 / (gu + gd);
        v = (gu * v1 + gd * v0) / (gu + gd);
    end

    always @(driver_update(d)) begin
        XCount = 0;
        ZCount = 0;
        LCount = 0;
        HCount = 0;
        for (i = 0;  i < DrCount;  i = i + 1) case
            ($driver_state(d, i)) 1'b0 : LCount = LCount + 1;
            1'b1 : HCount = HCount + 1;
            1'bx : begin
                XCount = XCount + 1;
                dout = 1'bx;
            end
            1'bz : ZCount = ZCount + 1;
        endcase
        gu = (XCount + HCount) * guon + (ZCount + LCount) * guoff;
        gd = (XCount + LCount) * gdon + (ZCount + HCount) * gdoff;
        r = 1.0 / (gu + gd);
        v = (gu * v1 + gd * v0) / (gu + gd);
    end

    always @(above(V(a) - vh)) begin
        vstate = 1;
        inXrange = 0;
    end
    always @(above(vh - V(a))) inXrange = 1;
    always @(above(V(a) - vl)) inXrange = 1;
    always @(above(vl - V(a))) begin
        vstate = 3;
        inXrange = 0;
    end

    always @(posedge inXrange) begin
        : XRangeDelay # xdelay vstate = 2;
        inXrange = 0;
    end
    always @(negedge inXrange) disable XRangeDelay;

    always @(posedge outOfZcurrent) begin
        : outOfZCurrentDelay # zdelay istate = 1;
        outOfZcurrent = 0;
    end
    always @(negedge outOfZcurrent) disable outOfZCurrentDelay;

    always @(above(abs(I(a)) - maxzi)) outOfZcurrent = 1;
    always @(above(maxzi - abs(I(a)))) begin
        istate = 0;
        outOfZcurrent = 0;
    end

    always @(vstate or istate or d) begin
        case
            (vstate) 1 : dout = (d === 1'bx) ? 1'bx : 1'b1;
            2 : dout = ((istate === 1'b0) & (d === 1'bz)) ? 1'bz : 1'bx;
            3 : dout = (d === 1'bx) ? 1'bx : 1'b0;
        endcase
    end

    analog begin
        V(a) <+ transition(v, 0, tr, tf) + transition(r, 0, tr, tf) * I(a);
    end
endmodule
