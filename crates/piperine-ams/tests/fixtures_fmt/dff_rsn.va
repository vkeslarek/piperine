// VerilogA for VerilogAmsLib, dff_rsn, veriloga

`include "constants.vams"
`include "disciplines.vams"

module dff_rsn(d, clk, q, _q, _rst, _set);
    input clk, d, _rst, _set;
    output q, _q;

    electrical q, _q, clk, d, _rst, _set;

    parameter real vlogic_high = 5;
    parameter real vlogic_low = 0;
    parameter real vtrans_clk = 2.5;
    parameter real vtrans = 2.5;
    parameter real tdel = 3u from [ 0 : inf);
    parameter real trise = 1u from(0 : inf);
    parameter real tfall = 1u from(0 : inf);

    integer x, rst_val, set_val;

    analog begin
        rst_val = (V(_rst) < vtrans);
        set_val = (V(_set) < vtrans);
        @(cross(V(clk) - vtrans_clk, 1)) x = (((V(d) > vtrans) || set_val) && !rst_val);
        @(cross(V(_rst) - vtrans, -1)) x = 0;
        @(cross(V(_set) - vtrans, -1)) x = !rst_val;

        V(q) <+ transition(vlogic_high * x + vlogic_low * !x, tdel, trise, tfall);
        V(_q) <+ transition(vlogic_high * !x + vlogic_low * x, tdel, trise, tfall);
    end

endmodule
