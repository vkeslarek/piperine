// Self-clocked (periodic) sample and hold
//
// Version 1a, 1 June 04
//
// Ken Kundert
//
// Downloaded from The Designer's Guide Community (www.designers-guide.org).
// Post any questions on www.designers-guide.org/Forum.
// Taken from "The Designer's Guide to Verilog-AMS" by Kundert & Zinke.
// Chapter 3, Listing 24.

`include "disciplines.vams"

module sh(p, n, ps, ns);
    parameter real period = 1 from(0 : inf);
    // sampling period (s)
    parameter real toff = 0 from [ 0 : inf);
    // offset time for sampling (s)
    parameter real td = 0 from [ 0 : inf);
    // delay from sampling to output (s)
    parameter real tt = period / 100 from [ 0 : inf);
    // duration of output transitions (s)
    input ps, ns;
    voltage ps, ns;
    // input port
    output p, n;
    voltage p, n;
    // output port
    real save;

    analog begin

        // Sample the input
        @(timer(toff, period) or initial_step) save = V(ps, ns);

        // Produce output with well-controlled transitions
        V(p, n) <+ transition(save, td, tt);
    end
endmodule
