// VerilogA for VerilogAmsLib, amp_dynamic, veriloga

`include "constants.vams"
`include "disciplines.vams"

module amp_dynamic(clk, rst, inp, inm, done, outp, outm);
    input clk;
    // Start amplification when rise
    input rst;
    // Reset when high
    input inp, inm;
    // Input
    output done;
    // Amplification done
    output outp, outm;
    // Output

    electrical clk, rst, inp, inm, done, outp, outm, clk_d, outp_pre, outm_pre;

    parameter real tamp = 10u;
    // Amplification time
    parameter real gain = 8;
    // Gain
    parameter real vcm = 2.5;
    // Common mode output voltage
    parameter real offset = 0;
    // Input referred offset
    parameter real vlogic_high = 5;
    parameter real vtrans = 2.5;
    parameter real tdel = 3u from [ 0 : inf);
    parameter real trise = 1u from(0 : inf);
    parameter real tfall = 1u from(0 : inf);

    real outDiff, gain, outp_val, outm_val;
    integer i, done_val;

    analog begin
        @(initial_step) begin
            done_val = 1;
        end

        V(clk_d) <+ transition(V(clk), tamp + 2 * tdel, trise, tfall);

        @(cross(V(clk) - vtrans, 1)) begin
            // Amplification start
            done_val = 0;
            outDiff = (V(inp) - V(inm) + offset) * gain;
            outp_val = vcm + outDiff / 2;
            outm_val = vcm - outDiff / 2;
        end

        @(cross(V(clk_d) - vtrans, 1)) begin
            // Amplification complete
            done_val = 1;
            outp_val = vcm;
            outm_val = vcm;
        end

        V(done) <+ transition(done_val * vlogic_high, tdel, trise, tfall);
        V(outp_pre) <+ transition(outp_val, tdel, tamp, tamp);
        V(outm_pre) <+ transition(outm_val, tdel, tamp, tamp);

        if (V(rst) > vtrans) begin
            // Reset
            done_val = 1;
            V(outp) <+ vcm + I(outp) * 1;
            // 1 ohm output impedance;
            V(outm) <+ vcm + I(outm) * 1;
        end
        else if (done_val == 0) begin
            // Amplification in progress
            V(outp) <+ V(outp_pre);
            V(outm) <+ V(outm_pre);
        end
    end

endmodule
