`include "constants.vams"
`include "disciplines.vams"

// Reflection interface

module ReflectionInterface(node1, node2);
    inout [ 0 : 3 ] node1;
    inout [ 0 : 3 ] node2;
    optical [ 0 : 3 ] node1, node2;

    parameter real reflection = 0;

    analog begin
        OptE(node1 [ 2 ]) <+ sqrt(1 - reflection) * OptE(node2 [ 2 ]) + sqrt(reflection) * OptE(node1 [ 0 ]);
        OptE(node1 [ 3 ]) <+ sqrt(1 - reflection) * OptE(node2 [ 3 ]) + sqrt(reflection) * OptE(node1 [ 1 ]);
        OptE(node2 [ 0 ]) <+ sqrt(1 - reflection) * OptE(node1 [ 0 ]) + sqrt(reflection) * OptE(node2 [ 2 ]);
        OptE(node2 [ 1 ]) <+ sqrt(1 - reflection) * OptE(node1 [ 1 ]) + sqrt(reflection) * OptE(node2 [ 3 ]);
    end
endmodule
