// Junction diode
//
// Version 1a, 1 June 04
//
// Ken Kundert
//
// Downloaded from The Designer's Guide Community (www.designers-guide.org).
// Post any questions on www.designers-guide.org/Forum.
// Taken from "The Designer's Guide to Verilog-AMS" by Kundert & Zinke.
// Chapter 3, Listing 11.

`include "disciplines.vams"

module diode(a, c);
    parameter real is = 10f from(0 : inf);
    // saturation current (A)
    parameter real tf = 0 from [ 0 : inf);
    // forward transit time (s)
    parameter real cjo = 0 from [ 0 : inf);
    // zero-bias junction capacitance (F)
    parameter real phi = 0.7 exclude 0;
    // built-in junction potential (V)
    inout a, c;
    electrical a, c;
    branch(a, c) res, cap;
    real qd;

    analog begin
        I(res) <+ is * (limexp(V(res) / $vt) - 1);
        qd = tf * I(res) - 2 * cjo * phi * sqrt(1 - V(cap) / phi);
        I(cap) <+ ddt(qd);
    end
endmodule
