// Verilog-AMS file that exercises every P1 gap.
// This file must parse without error after all P1 fixes are applied.

// Gap 2: module with parameter port list
module amp # (
    parameter real gain = 10.0,
    parameter real bw = 1e6) (in, out);
    input
    electrical in;
    output
    electrical out;
    // Gap 3: specparam
    specparam tpd = 2.5e-9 : 3e-9 : 4e-9;
    // Gap 4: specify block
    specify specparam trise = 1e-9;
    (in = > out) = tpd;
    endspecify  // Gap 5: gate instantiation
    wire w;
    and g1(w, in, in);
    not inv1(out, w);
    // Gap 1: task
    task automatic bias_check;
        input real v;
        if (v < 0.0) $warning("negative bias %g", v);
    endtask
    analog V(out) <+ gain * V(in);
endmodule

// Gap 10: UDP (P2, but shown here)
primitive inv_udp(out, in);
output out;
input in;
table 0 : 1;
1 : 0;
x : x;
endtable endprimitive
