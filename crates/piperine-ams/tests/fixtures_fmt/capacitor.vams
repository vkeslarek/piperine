// Linear capacitor
//
// Version 1a, 1 June 04
//
// Ken Kundert
//
// Downloaded from The Designer's Guide Community (www.designers-guide.org).
// Post any questions on www.designers-guide.org/Forum.
// Taken from "The Designer's Guide to Verilog-AMS" by Kundert & Zinke.
// Chapter 3, Listing 3.

`include "disciplines.vams"

module capacitor(p, n);
    parameter real c = 0;
    // capacitor (F)
    inout p, n;
    electrical p, n;

    analog I(p, n) <+ c * ddt(V(p, n));
endmodule
