// Various Capacitor Models
//
// Version 1a, 11 Apr 03
//
// Ken Kundert
//
// Downloaded from The Designer's Guide (www.designers-guide.org).
// Post any questions on www.designers-guide.org/Forum.

`include "disciplines.vams"
`include "constants.vams"

// Simple Capacitor Model

module cap1(p, n);

    inout p, n;
    electrical p, n;
    parameter real c = 1 from [ 0 : inf);

    analog begin
        I(p, n) <+ c * ddt(V(p, n));
    end
endmodule

// Capacitor Model that Supports Initial Conditions
//
// Initial condition is not applied during DC analysis.
// Be sure to provide DC path across capacitor to avoid failure of DC analysis.
// Uncomment gmin lines to do this in model.

module cap2(p, n);

    inout p, n;
    electrical p, n;
    parameter real c = 1 from [ 0 : inf);
    parameter real ic = 0;
    // parameter real gmin=1e-12;

    analog begin
        if (analysis("ic")) V(p, n) <+ ic;
        else I(p, n) <+ c * ddt(V(p, n));
        // I(p,n) <+ gmin*V(p,n);
    end
endmodule
