// Logic controlled switch
//
// Version 1a, 1 June 04
//
// Olaf Zinke
//
// Downloaded from The Designer's Guide Community (www.designers-guide.org).
// Post any questions on www.designers-guide.org/Forum.
// Taken from "The Designer's Guide to Verilog-AMS" by Kundert & Zinke.
// Chapter 4, Listing 10.

`include "disciplines.vams"

module sw(p, n, s);
    input s;
    output p, n;
    logic s;
    electrical p, n;

    analog begin
        if (s) V(p, n) <+ 0.0;
        else I(p, n) <+ 0.0;
    end
endmodule
