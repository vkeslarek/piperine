// N-bit Analog to Digital Converter
//
// Version 1c, 10 February 08
//
// Ken Kundert
//
// Downloaded from The Designer's Guide Community (www.designers-guide.org).
// Post any questions on www.designers-guide.org/Forum.
// Taken from "The Designer's Guide to Verilog-AMS" by Kundert & Zinke.
// Chapter 3, Listing 26.
//
// This version of the ADC was modified to work in the existing
// version of Spectre (6.1.1 May 2007).

`include "disciplines.vams"

module adc(out, in, clk);
    // parameter integer bits = 8 from [1:24];
    `define bits 8  // resolution (bits)
    parameter real fullscale = 1.0;
    // input range is from 0 to fullscale (V)
    parameter real td = 0;
    // delay from clock edge to output (s)
    parameter real tt = 0;
    // transition time of output (s)
    parameter real vdd = 5.0;
    // voltage level of logic 1 (V)
    parameter real thresh = vdd / 2;
    // logic threshold level (V)
    parameter integer dir = 1 from [ - 1 : 1 ] exclude 0;
    // 1 for rising edges, -1 for falling
    input in, clk;
    output [ 0 : `bits - 1 ] out;
    voltage in, clk;
    voltage [ 0 : `bits - 1 ] out;
    real sample, midpoint;
    integer result [ 0 : `bits - 1 ];
    integer i;

    analog begin
        @(cross(V(clk) - thresh, dir) or initial_step) begin
            sample = V(in);
            midpoint = fullscale / 2.0;
            for (i = `bits - 1;  i >= 0;  i = i - 1) begin
                if (sample > midpoint) begin
                    result [ i ] = 1;
                    sample = sample - midpoint;
                end
                else begin
                    result [ i ] = 0;
                end
                sample = 2.0 * sample;
            end
        end
        generate
            i(`bits - 1, 0) begin
                V(out [ i ]) <+ transition(result [ i ] ? vdd : 0.0, td, tt);
            end
        end
    endmodule
    `undef bits
