// VerilogA for VerilogAmsLib, tah_ideal, veriloga

`include "constants.vams"
`include "disciplines.vams"

module tah_ideal(clk, in, out);
    input clk;
    // Track when high, hold when low
    input in;
    inout out;

    electrical clk, in, out;

    parameter real ron = 25;
    parameter real vtrans_clk = 2.5;

    real iout;
    genvar i;

    analog begin
        @(initial_step) begin
            iout = 0;
        end

        @(cross(V(clk) - vtrans_clk, 1)) begin
            iout = 0;
        end

        if (V(clk) < vtrans_clk) begin
            iout = V(out, in) / ron;
        end

        I(out) <+ iout;
        I(in) <+ -iout;
    end

endmodule
