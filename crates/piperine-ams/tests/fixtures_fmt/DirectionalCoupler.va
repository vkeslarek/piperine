`include "constants.vams"
`include "disciplines.vams"

// Two-by-two directional coupler

module DirectionalCoupler(in1, in2, out1, out2);
    inout [ 0 : 3 ] in1, in2, out1, out2;
    optical [ 0 : 3 ] in1, in2, out1, out2;

    parameter real kappa = 0.5;
    // Power ratio

    analog begin
        OptE(out1 [ 0 ]) <+ sqrt(1 - kappa) * OptE(in1 [ 0 ]) + sqrt(kappa) * OptE(in2 [ 1 ]);
        OptE(out1 [ 1 ]) <+ sqrt(1 - kappa) * OptE(in1 [ 1 ]) - sqrt(kappa) * OptE(in2 [ 0 ]);
        OptE(out2 [ 0 ]) <+ sqrt(1 - kappa) * OptE(in2 [ 0 ]) + sqrt(kappa) * OptE(in1 [ 1 ]);
        OptE(out2 [ 1 ]) <+ sqrt(1 - kappa) * OptE(in2 [ 1 ]) - sqrt(kappa) * OptE(in1 [ 0 ]);
        OptE(in1 [ 2 ]) <+ sqrt(1 - kappa) * OptE(out1 [ 2 ]) + sqrt(kappa) * OptE(out2 [ 2 ]);
        OptE(in1 [ 3 ]) <+ sqrt(1 - kappa) * OptE(out1 [ 3 ]) - sqrt(kappa) * OptE(out2 [ 3 ]);
        OptE(in2 [ 2 ]) <+ sqrt(1 - kappa) * OptE(out2 [ 2 ]) + sqrt(kappa) * OptE(out1 [ 2 ]);
        OptE(in2 [ 3 ]) <+ sqrt(1 - kappa) * OptE(out2 [ 3 ]) - sqrt(kappa) * OptE(out1 [ 3 ]);
    end
endmodule
