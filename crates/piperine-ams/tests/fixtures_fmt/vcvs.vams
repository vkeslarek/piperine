// Voltage-controlled voltage source
//
// Version 1a, 1 June 04
//
// Ken Kundert
//
// Downloaded from The Designer's Guide Community (www.designers-guide.org).
// Post any questions on www.designers-guide.org/Forum.
// Taken from "The Designer's Guide to Verilog-AMS" by Kundert & Zinke.
// Chapter 3, Listing 13.

`include "disciplines.vams"

module vcvs(p, n, ps, ns);
    parameter real gain = 1;
    // voltage gain (V/V)
    output p, n;
    input ps, ns;
    electrical p, n, ps, ns;

    analog V(p, n) <+ gain * V(ps, ns);
endmodule
