`include "constants.vams"
`include "disciplines.vams"

// Optical phase shifter

module PhaseShifter(in, out);
    inout [ 0 : 3 ] in, out;
    optical [ 0 : 3 ] in, out;
    optical [ 0 : 1 ] transfer_pol, transfer;

    parameter real phase = 90;
    // Phase delay [degree]

    Polar2Cartesian Polar2Cartesian1(transfer_pol, transfer);
    CartesianMultiplier CartesianMultiplier1(transfer, in [ 0 : 1 ], out [ 0 : 1 ]);
    CartesianMultiplier CartesianMultiplier2(transfer, out [ 2 : 3 ], in [ 2 : 3 ]);

    analog begin
        OptE(transfer_pol [ 0 ]) <+ 1;
        // Amplitude
        OptE(transfer_pol [ 1 ]) <+ (-phase / 180 * `M_PI) % (2 * `M_PI);  // Angle
    end
endmodule
