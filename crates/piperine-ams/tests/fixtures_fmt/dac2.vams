// N-bit Digital to Analog Converter
//
// Version 1a, 1 June 04
//
// Ken Kundert
//
// Downloaded from The Designer's Guide Community (www.designers-guide.org).
// Post any questions on www.designers-guide.org/Forum.
// Taken from "The Designer's Guide to Verilog-AMS" by Kundert & Zinke.
// Chapter 3, Listing 27.
//
// This version of the DAC was modified to work in the existing
// version of Spectre (5.0 May 2003).

`include "disciplines.vams"

module dac(out, in, clk);
    // parameter integer bits = 8 from [1:24];
    `define bits 8  // resolution (bits)
    parameter real fullscale = 1.0;
    // output range is from 0 to fullscale (V)
    parameter real td = 0;
    // delay from clock edge to output (s)
    parameter real tt = 0;
    // transition time of output (s)
    parameter real vdd = 5.0;
    // voltage level of logic 1 (V)
    parameter real thresh = vdd / 2;
    // logic threshold level (V)
    parameter integer dir = 1 from [ - 1 : 1 ] exclude 0;
    // 1 for rising edges, -1 for falling
    output out;
    input [ 0 : `bits - 1 ] in;
    input clk;
    voltage out, clk;
    voltage [ 0 : `bits - 1 ] in;
    real aout;
    integer weight;
    integer i;

    analog begin
        @(cross(V(clk) - thresh, dir) or initial_step) begin
            aout = 0;
            weight = 2;
            generate
                i(`bits - 1, 0) begin
                    if (V(in [ i ]) > thresh) begin
                        aout = aout + fullscale / weight;
                    end
                    weight = weight * 2;
                end
            end
            V(out) <+ transition(aout, td, tt);
        end
    endmodule
    `undef bits
