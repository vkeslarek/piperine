// Varactor Model
//
// Version 1b, 23 October 2006
//
// Ken Kundert
//
// downloaded from the designer's guide (www.designers-guide.org).
// post any questions on www.designers-guide.org/forum.
// Documentation on the model can be found at www.designers-guide.org/Modeling

`include "disciplines.vams"

module varactor(p, n);
    inout p, n;
    electrical p, n;
    parameter real c0 = 1p from(0 : inf);
    // nominal capacitance (F)
    parameter real c1 = 0.5p from [ 0 : c0);
    // maximum capacitance change from nominal (F)
    parameter real v0 = 0;
    // voltage for nominal capacitance (V)
    parameter real v1 = 1 from(0 : inf);
    // voltage change for maximum capacitance (V)
    real q, v;

    analog begin
        v = V(p, n);
        q = c0 * v + c1 * v1 * ln(cosh((v - v0) / v1));
        I(p, n) <+ ddt(q);
    end
endmodule
