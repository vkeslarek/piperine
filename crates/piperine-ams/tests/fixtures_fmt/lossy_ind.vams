// Lossy Inductor
//
// Version 1a, 1 June 04
//
// Ken Kundert
//
// Downloaded from The Designer's Guide Community (www.designers-guide.org).
// Post any questions on www.designers-guide.org/Forum.
// Taken from "The Designer's Guide to Verilog-AMS" by Kundert & Zinke.
// Chapter 3, Listing 28.

`include "disciplines.vams"
`include "constants.vams"

module lossy_ind(t1, t2);
    parameter real esr = 0.01 from(0 : inf);
    // equivalent series resistance (Ohms)
    parameter real rcp = 1.0 from(0 : inf);
    // series resistance of shunt C (Ohms)
    parameter real cp = 10f from(0 : inf);
    // shunt capacitance (F)
    parameter real l = 1n from(0 : inf);
    // inductance (H)
    parameter real h = 70K from(1 : inf);
    // magnitude of skin effect at 1Hz (Ohms)
    inout t1, t2;
    electrical t1, t2;
    electrical n1, n2;

    resistor # (.r(rcp)) Rp(n2, t2);
    skin_effect # (.r0(esr),.f0(2 * esr * esr * h * h),.f1(1 / (2 * `M_PI * sqrt(l * cp)))) Hr(t1, n1);
    capacitor # (.c(cp)) Cp(t1, n2);
    inductor # (.l(l)) L(n1, t2);
endmodule
