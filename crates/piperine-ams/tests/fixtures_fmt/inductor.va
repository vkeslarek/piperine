// Various Inductor Models
//
// Version 1a, 11 Apr 03
//
// Ken Kundert
//
// Downloaded from The Designer's Guide (www.designers-guide.org).
// Post any questions on www.designers-guide.org/Forum.

`include "disciplines.vams"

// Simple Inductor Model

module ind1(p, n);

    inout p, n;
    electrical p, n;
    parameter real l = 1 from [ 0 : inf);

    analog begin
        V(p, n) <+ l * ddt(I(p, n));
    end
endmodule

// Inductor Model with Series Resistance

module ind2(p, n);

    inout p, n;
    electrical p, n;
    parameter real l = 1 from [ 0 : inf);
    parameter real r = 0 from [ 0 : inf);

    analog begin
        V(p, n) <+ l * ddt(I(p, n)) + r * I(p, n);
    end
endmodule
