`include "constants.vams"
`include "disciplines.vams"

// Complex multiplier in Cartesian coordinates

module CartesianMultiplier(cartin1, cartin2, cartout);
    input [ 0 : 1 ] cartin1, cartin2;
    output [ 0 : 1 ] cartout;
    optical [ 0 : 1 ] cartin1, cartin2, cartout;

    analog begin
        OptE(cartout [ 0 ]) <+ OptE(cartin1 [ 0 ]) * OptE(cartin2 [ 0 ]) - OptE(cartin1 [ 1 ]) * OptE(cartin2 [ 1 ]);
        OptE(cartout [ 1 ]) <+ OptE(cartin1 [ 0 ]) * OptE(cartin2 [ 1 ]) + OptE(cartin1 [ 1 ]) * OptE(cartin2 [ 0 ]);
    end
endmodule
