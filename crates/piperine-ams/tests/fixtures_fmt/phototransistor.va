//   Qucs compact phototransistor model
//   The structure and theoretical background to the phototransistor
//   Verilog-A model are given in the COMON meeting demonstration
//   at link http://www.mos-ak.org/frankfurt_o/papers/M_Brinson_Qucs_COMON_April_2_2009_final.pdf.
//
//   This is free software; you can redistribute it and/or modify
//   it under the terms of the GNU General Public License as published by
//   the Free Software Foundation; either version 2, or (at your option)
//   any later version.
//
//   Copyright (C), Mike Brinson, mbrin72043@yahoo.co.uk, March 2009.
//
`include "disciplines.vams"
`include "constants.vams"
`define GMIN $simparam("gmin", 1e-12)
module phototransistor(Collector, Base, Emitter, LightPower, Wavelength);
    inout Collector, Base, Emitter, LightPower, Wavelength;
    electrical Collector, Base, Emitter, LightPower, Wavelength;
    electrical CI, BI, BI2, EI;
    //
    (* desc = "forward beta" *)
    parameter real Bf = 100 from [ 1 : inf);
    (* desc = "reverse beta" *)
    parameter real Br = 0.1 from [ 1e-6 : inf);
    (* desc = "dark current", unit = "A" *)
    parameter real Is = 1e-10 from [ 1e-30 : inf);
    (* desc = "forward emission coefficient" *)
    parameter real Nf = 1 from [ 1e-30 : inf);
    (* desc = "reverse emission coefficient" *)
    parameter real Nr = 1 from [ 1e-30 : inf);
    (* desc = "forward early voltage", unit = "V" *)
    parameter real Vaf = 100 from [ 1e-6 : inf);
    (* desc = "reverse early voltage", unit = "V" *)
    parameter real Var = 100 from [ 1e-6 : inf);
    (* desc = "base-emitter junction exponential factor" *)
    parameter real Mje = 0.33 from [ 1e-6 : inf);
    (* desc = "base-emitter junction built-in potential", unit = "V" *)
    parameter real Vje = 0.75 from [ 1e-6 : inf);
    (* desc = "base-emitter zero-bias depletion capacitance", unit = "F" *)
    parameter real Cje = 1e-12 from [ 0 : inf);
    (* desc = "base-collector junction exponential factor" *)
    parameter real Mjc = 0.33 from [ 1e-6 : inf);
    (* desc = "base-collector junction built-in potential", unit = "V" *)
    parameter real Vjc = 0.75 from [ 1e-6 : inf);
    (* desc = "base-collector zero-bias depletion capacitance", unit = "F" *)
    parameter real Cjc = 2e-12 from [ 0 : inf);
    (* desc = "ideal reverse transit time", unit = "s" *)
    parameter real Tr = 100n from [ 1e-15 : inf);
    (* desc = "ideal forward transit time", unit = "s" *)
    parameter real Tf = 0.1n from [ 1e-15 : inf);
    (* desc = "high current corner for forward beta", unit = "A" *)
    parameter real Ikf = 10 from [ 1e-20 : inf);
    (* desc = "high current corner for reverse beta", unit = "A" *)
    parameter real Ikr = 10 from [ 1e-20 : inf);
    (* desc = "collector series resistance", unit = "Ohm" *)
    parameter real Rc = 10 from [ 1e-9 : inf);
    (* desc = "emitter series resistance", unit = "Ohm" *)
    parameter real Re = 1 from [ 1e-9 : inf);
    (* desc = "base series resistance", unit = "Ohm" *)
    parameter real Rb = 100 from [ 1e-9 : inf);
    (* desc = "flicker noise coefficient" *)
    parameter real Kf = 1e-12 from [ 0 : inf);
    (* desc = "flicker noise coefficient" *)
    parameter real Ffe = 1 from [ 0 : inf);
    (* desc = "flicker noise exponent" *)
    parameter real Af = 1 from [ 0 : inf);
    (* desc = "responsivity at relative selectivity=100%", unit = "A/W" *)
    parameter real Responsivity = 1.5 from [ 1e-30 : inf);
    (* desc = "relative selectivity polynomial coefficient" *)
    parameter real P0 = 2.6122e3 from(-inf : inf);
    (* desc = "relative selectivity polynomial coefficient" *)
    parameter real P1 = -1.489e1 from(-inf : inf);
    (* desc = "relative selectivity polynomial coefficient" *)
    parameter real P2 = 3.0332e-2 from(-inf : inf);
    (* desc = "relative selectivity polynomial coefficient" *)
    parameter real P3 = -2.5708e-5 from(-inf : inf);
    (* desc = "relative selectivity polynomial coefficient" *)
    parameter real P4 = 7.6923e-9 from(-inf : inf);
    //
    real VT, con1, con2, con3, con4, con5, con6, con7, con8, con9, con10;
    real TwoQ, FourKT;
    real ICC, IEC, q1, q2, IB, IC, IE, Q1, RelSensitivity;
    //
    analog begin
        @(initial_step) begin
            VT = `P_K * 300 / `P_Q;  // VT = vt(300)
            con1 = 1 / (Nf * VT);
            con2 = 1 / (Nr * VT);
            con3 = 1 - Mje;
            con4 = 1 - Mjc;
            con5 = pow(2, Mje);
            con6 = pow(2, Mjc);
            con7 = Rb / 2;
            con8 = 2 / Rb;
            con9 = 1 / Rc;
            con10 = 1 / Re;
            TwoQ = 2 * `P_Q;  // TwoQ = 2*q
            FourKT = 4 * `P_K * $temperature;  // FourKT = 4*K*T
            //            GMIN=1e-12;
        end
        // Model quantity equations and current contributions
        ICC = Is * (limexp(V(BI, EI) * con1) - 1);
        IEC = Is * (limexp(V(BI, CI) * con2) - 1);
        q1 = 1 + V(BI, CI) / Vaf + V(BI, EI) / Var;
        q2 = (ICC / Ikf) + (IEC / Ikr);
        IB = V(BI2, BI) * con8;
        IC = V(Collector, CI) * con9;
        IE = V(EI, Emitter) * con10;
        I(Collector, CI) <+ IC;
        I(Base, BI2) <+ V(Base, BI2) * con8;
        I(BI2, BI) <+ IB;
        I(EI, Emitter) <+ IE;
        I(BI, CI) <+ (IEC / Br) + `GMIN * V(BI, CI);
        I(BI, EI) <+ (ICC / Bf) + `GMIN * V(BI, EI);
        I(CI, EI) <+ (ICC - IEC) / (1e-20 + (q1 / 2) * (1 + sqrt(1 + 4 * q2)));
        Q1 = (V(BI, CI) > Vjc / 2) ? Tr * IEC + Cjc * con6 * (Mjc * V(BI, CI) * V(BI, CI) / Vjc + con4 * V(BI, CI)) : Tr * IEC + Cjc * ((Vjc / con4) * (1 - pow((1 - V(BI, CI)), con4)));
        I(BI, CI) <+ ddt(Q1);
        Q1 = (V(BI, EI) > Vje / 2) ? Tf * ICC + Cje * con5 * (Mje * V(BI, EI) * V(BI, EI) / Vje + con3 * V(BI, EI)) : Tf * ICC + Cje * ((Vje / con3) * (1 - pow((1 - V(BI, EI)), con3)));
        I(BI, EI) <+ ddt(Q1);
        RelSensitivity = P0 + P1 * V(Wavelength) + P2 * pow(V(Wavelength), 2.0) + P3 * pow(V(Wavelength), 3.0) + P4 * pow(V(Wavelength), 4.0);
        I(CI, BI2) <+ ((Responsivity * RelSensitivity) / (Bf * 100)) * V(LightPower);
        // Noise contributions
        I(Collector, CI) <+ white_noise(FourKT * con9, "thermal");
        I(Base, BI2) <+ white_noise(FourKT * con8, "thermal");
        I(BI2, BI) <+ white_noise(FourKT * con8, "thermal");
        I(EI, Emitter) <+ white_noise(FourKT * con10, "thermal");
        I(CI, EI) <+ white_noise(TwoQ * IC, "shot");
        I(BI, EI) <+ white_noise(TwoQ * IB, "shot");
        I(BI, EI) <+ flicker_noise(Kf * pow(IB, Af), Ffe, "flicker");
    end
endmodule
