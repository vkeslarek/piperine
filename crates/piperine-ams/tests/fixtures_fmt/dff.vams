// D-Flip Flop
//
// Version 1a, 1 June 04
//
// Ken Kundert
//
// Downloaded from The Designer's Guide Community (www.designers-guide.org).
// Post any questions on www.designers-guide.org/Forum.
// Taken from "The Designer's Guide to Verilog-AMS" by Kundert & Zinke.
// Chapter 5, Listing 3.

`include "disciplines.vams"

module dff(q, d, clk);
    parameter integer dir = +1 from [ - 1 : +1 ] exclude 0;
    // if dir=+1, rising clock edge triggers flip flop
    // if dir=-1, falling clock edge triggers flip flop
    output q;
    voltage q;
    // Q output
    input clk;
    voltage clk;
    // Clock input (edge triggered)
    input d;
    voltage d;
    // D input
    integer state;

    analog begin
        @(cross(V(clk) - 0.5, dir)) state = (V(d) > 0.5);
        V(q) <+ transition(state ? 1 : 0);
    end
endmodule
