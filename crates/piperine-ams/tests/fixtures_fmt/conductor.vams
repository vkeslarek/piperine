// Linear resistor
//
// Uses the conductance formulation (I = GV, where G = 1/R)
// Best for large valued resistors, conductance may be 0.
//
// Version 1a, 1 June 04
//
// Ken Kundert
//
// Downloaded from The Designer's Guide Community (www.designers-guide.org).
// Post any questions on www.designers-guide.org/Forum.
// Taken from "The Designer's Guide to Verilog-AMS" by Kundert & Zinke.
// Chapter 3, Listing 2.

`include "disciplines.vams"

module conductor(p, n);
    parameter real g = 0;
    // conductance (Siemens)
    inout p, n;
    electrical p, n;

    analog I(p, n) <+ g * V(p, n);
endmodule
