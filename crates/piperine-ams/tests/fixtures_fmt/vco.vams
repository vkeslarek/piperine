// Voltage Controlled Oscillator
//
// Version 1a, 1 June 04
//
// Olaf Zinke
//
// Downloaded from The Designer's Guide Community (www.designers-guide.org).
// Post any questions on www.designers-guide.org/Forum.
// Taken from "The Designer's Guide to Verilog-AMS" by Kundert & Zinke.
// Appendix A, Listing 8.

`include "disciplines.vams"
`timescale 1ns / 1ps

module vco(out, ps, ns);
    parameter real f0 = 100k;
    // center frequency (Hz)
    parameter real kvco = 10k;
    // gain (Hz/V)
    parameter real rin = 100k from(0 : inf);
    // input resistance (Ohms)
    output out;
    electrical ps, ns;
    reg out;
    logic out;
    real vin;

    initial out = 0;

    always begin
        vin = V(ps, ns);
        # (0.5e9 / (f0 + kvco * vin)) out = ~out;
    end

    analog I(ps, ns) <+ V(ps, ns) / rin;
endmodule
