// Time Interval Measurement
//
// Version 1a, 1 June 04
//
// Ken Kundert
//
// Downloaded from The Designer's Guide Community (www.designers-guide.org).
// Post any questions on www.designers-guide.org/Forum.
// Taken from "The Designer's Guide to Verilog-AMS" by Kundert & Zinke.
// Chapter 3, Listing 25.

`include "disciplines.vams"

module time_interval_measurement(arm, trigger);
    parameter real thresh = 0;
    // threshold (V)
    parameter integer dir = 1 from [ - 1 : 1 ] exclude 0;
    // 1 for rising edges, -1 for falling
    input arm, trigger;
    voltage arm, trigger;
    integer count, armed;
    real t0, t1, sum, mean;
    analog begin
        t0 = last_crossing(V(arm) - thresh, dir);
        @(cross(V(arm) - thresh, dir)) armed = 1;
        t1 = last_crossing(V(trigger) - thresh, dir);
        @(cross(V(trigger) - thresh, dir)) begin
            if (armed) begin
                armed = 0;
                count = count + 1;
                sum = sum + (t1 - t0);
            end
        end
        @(final_step) begin
            $strobe("time interval measurements = %d.\n", count);
            if (count) begin
                mean = sum / count;
                $strobe("mean time interval (est)= %g.\n", mean);
            end
            else $strobe("Could not measure the time interval.\n");
        end
    end
endmodule
