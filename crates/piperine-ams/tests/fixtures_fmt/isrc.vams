// DC current source
//
// Version 1a, 1 June 04
//
// Ken Kundert
//
// Downloaded from The Designer's Guide Community (www.designers-guide.org).
// Post any questions on www.designers-guide.org/Forum.
// Taken from "The Designer's Guide to Verilog-AMS" by Kundert & Zinke.
// Chapter 3, Listing 6.

`include "disciplines.vams"

module isrc(p, n);
    parameter real dc = 0;
    // dc current (A)
    output p, n;
    electrical p, n;

    analog I(p, n) <+ dc;
endmodule
