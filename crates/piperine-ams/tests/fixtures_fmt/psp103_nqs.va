//======================================================================================
//======================================================================================
// Filename: psp103_nqs.va
//======================================================================================
//======================================================================================
//
//  (c) Copyright notice
//
//  Copyright 2004-2017 NXP Semiconductors, 2015-2017 Commissariat a l’energie atomique
//  et aux energies alternatives (CEA), 2012-2015 Delft University of Technology and
//  2004-2011 Arizona State University Licensed under the Educational Community License,
//  Version 2.0 (the "License"); you may not use this file except in compliance with the
//  License. You may obtain a copy of the License at
//  http://opensource.org/licenses/ECL-2.0
//  Unless required by applicable law or agreed to in writing, software distributed under
//  the License is distributed on an "AS IS" BASIS, WITHOUT WARRANTIES OR CONDITIONS OF
//  ANY KIND, either express or implied. See the License for the specific language
//  governing permissions and limitations under the License.
//
//
//  Version: 103.6.0 (PSP), 200.5.0 (JUNCAP), December 2017
//
//======================================================================================
//======================================================================================
//
// Further information can be found in the file releasenotesPSP103.txt
//

`include "discipline.h"

`define NQSmodel true

`include "Common103_macrodefs.include"

`include "JUNCAP200_macrodefs.include"

`include "PSP103_macrodefs.include"

// Note: some verilog-A compilers have problems handling the ddx-operator,
// which occurs in definition of OP-output variables. If the line below is
// commented out, all OP-output variables using the ddx-operator are skipped.
`define OPderiv

/////////////////////////////////////////////////////////////////////////////
//
//  PSP global model code
//
/////////////////////////////////////////////////////////////////////////////

`include "PSP103_nqs_macrodefs.include"

module PSPNQS103VA(D, G, S, B);

    `include "PSP103_module.include"

endmodule
