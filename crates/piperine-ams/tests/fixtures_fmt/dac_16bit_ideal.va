// VerilogA for VerilogAmsLib, dac_16bit_ideal, veriloga

`include "constants.vams"
`include "disciplines.vams"

`define NUM_DAC_BITS 16

module dac_16bit_ideal(in, out);
    input [ `NUM_DAC_BITS - 1 : 0 ] in;
    output out;

    electrical in [ `NUM_DAC_BITS - 1 : 0 ], out;

    parameter real vref = 1 from(0 : inf);
    parameter real vtrans = 2.5;
    parameter real tdel = 3u from [ 0 : inf);
    parameter real trise = 1u from(0 : inf);
    parameter real tfall = 1u from(0 : inf);

    real out_scaled;
    // output scaled as fraction of 256
    integer i;

    analog begin
        out_scaled = 0;
        for (i = 0;  i < `NUM_DAC_BITS;  i = i + 1) begin
            out_scaled = out_scaled + ((V(in [ i ]) > vtrans) ? (1 << i) : 0);
        end
        V(out) <+ transition(vref * out_scaled / (1 << `NUM_DAC_BITS), tdel, trise, tfall);
    end

endmodule

`undef NUM_DAC_BITS
