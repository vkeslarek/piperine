// VerilogA for VerilogAmsLib, ohmmeter, veriloga

`include "constants.vams"
`include "disciplines.vams"

module ohmmeter(dutp, dutm, iprobe, r, g);
    input dutp, iprobe;
    output dutm, r, g;

    electrical dutp, dutm, iprobe, r, g;

    parameter real max_resistance = 1k;
    parameter real min_resistance = -1;
    parameter real max_conductance = 1;
    parameter real min_conductance = -1;

    real r_val, g_val;

    analog begin
        V(dutm, iprobe) <+ 0;
        r_val = V(dutp, dutm) / I(iprobe);
        g_val = I(iprobe) / V(dutp, dutm);
        if (r_val > max_resistance) begin
            r_val = max_resistance;
        end
        if (r_val < min_resistance) begin
            r_val = min_resistance;
        end
        if (g_val > max_conductance) begin
            g_val = max_conductance;
        end
        if (g_val < min_conductance) begin
            g_val = min_conductance;
        end
        V(r) <+ r_val;
        V(g) <+ g_val;
    end

endmodule
