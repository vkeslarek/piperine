// Test series RLC models

simulator lang=spectre

ahdl_include "series_rlc.vams"

V1  (n1 0)  vsource type=pulse
X1  (n1 0)  series_rlc1 r=1 l=1uH c=1uH
V2  (n2 0)  vsource type=pulse
X2  (n2 0)  series_rlc2 r=1 l=1uH c=1uH

doDC dc print=yes
doTran tran stop=10us
