// Test sample and hold

simulator lang=spectre

ahdl_include "sh.vams"

Vin (in 0) vsource type=sine ampl=1 freq=1MHz
Sh  (out 0 in 0) sh period=1.1us

doTran tran stop=20us
