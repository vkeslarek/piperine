`timescale 10ns / 10ps
`include "disciplines.vams"

module testbench ();
    electrical gnd;
    ground gnd;
    wire out;

    vco #(.f0(100M), .kvco(10M)) vco0 (out, in, gnd);
    vsource #(.type("sine"), .ampl(0.5), .dc(0.5), .freq(1M)) v0 (in, gnd);
    freq_meas freq_measurement (out);
endmodule
