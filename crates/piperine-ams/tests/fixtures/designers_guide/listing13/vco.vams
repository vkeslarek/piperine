// Voltage Controlled Oscillator
//
// Version 1a, 1 June 04
//
// Olaf Zinke
//
// Downloaded from The Designer's Guide Community (www.designers-guide.org).
// Post any questions on www.designers-guide.org/Forum.
// Taken from "The Designer's Guide to Verilog-AMS" by Kundert & Zinke.
// Chapter 4, Listing 13.

`timescale 1ns / 1ps
`include "disciplines.vams"

module vco (out, ps, ns);
    parameter real f0 = 100k from (0:inf);	// center frequency (Hz)
    parameter real kvco = 10k;			// gain (Hz/V)
    input ps, ns;
    output out;
    electrical ps, ns;
    reg out;
    logic out;
    real vin;

    initial out = 0;

    always begin
	vin = V(ps, ns);
	#(0.5e9 / (f0 + kvco * vin))
	out = ~out;
    end
endmodule
