// Test vcvs model

simulator lang=spectre

ahdl_include "vcvs.vams"

Vin (in 0) vsource type=dc dc=1
E1  (out 0 in 0) vcvs gain=2
R1  (out 0) resistor r=1

doDC dc print=yes
