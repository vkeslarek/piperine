// Electrical to Logic Connect Module
//
// Version 1a, 1 June 04
//
// Olaf Zinke
//
// Downloaded from The Designer's Guide Community (www.designers-guide.org).
// Post any questions on www.designers-guide.org/Forum.
// Taken from "The Designer's Guide to Verilog-AMS" by Kundert & Zinke.
// Chapter 4, Listing 16.

`include "disciplines.vams"

connectmodule a2d (out, in);
    parameter real vh = 2.7;	// minimum voltage of a logic 1 (V)
    parameter real vl = 0.5;	// maximum voltage of a logic 0 (V)
    parameter real c = 100f;	// input capacitance (F)
    input in;
    output out;
    electrical in;
    reg out;
    logic out;

    // when analog rises above the high threshold, digital becomes 1
    always @(above(V(in) - vh))
	out = 1'b1;

    // when analog falls below the low threshold, digital becomes 0
    always @(above(vl - V(in)))
	out = 1'b0;

    analog
	I(in) <+ c*ddt(V(in));
endmodule
