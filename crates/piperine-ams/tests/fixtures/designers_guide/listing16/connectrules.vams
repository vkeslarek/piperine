`include "disciplines.vams"

connectrules my_connectrules;
    connect a2d;
endconnectrules
