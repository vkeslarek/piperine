// Comparator
//
// Version 1a, 1 June 04
//
// Ken Kundert
//
// Downloaded from The Designer's Guide Community (www.designers-guide.org).
// Post any questions on www.designers-guide.org/Forum.
// Taken from "The Designer's Guide to Verilog-AMS" by Kundert & Zinke.
// Chapter 5, Listing 5.

`include "disciplines.vams"

module comparator(out, pin, nin);
    parameter real td = 1n;	// time delay (s)
    parameter real tt = 1n;	// output transition time (s)
    output out;
    input pin, nin;
    voltage out, pin, nin;
    real Vout;

    analog begin
	@(cross(V(pin) - V(nin), 0))
	    ;
	Vout = ((V(pin) > V(nin)) ? 1 : 0);
	V(out) <+ transition(Vout, td, tt);
    end
endmodule
