// Test Comparator model

simulator lang=spectre

ahdl_include "comparator.vams"

Vclk (in 0) vsource type=sine ampl=1 freq=1MHz
A1   (out in 0) comparator td=100ns tt=100ns

doTran tran stop=2u
