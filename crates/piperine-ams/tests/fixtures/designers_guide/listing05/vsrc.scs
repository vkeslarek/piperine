// Test voltage source model

simulator lang=spectre

ahdl_include "vsrc.vams"

V1 (v 0) vsrc dc=1
R1 (v 0) resistor r=1

doDC dc print=yes
