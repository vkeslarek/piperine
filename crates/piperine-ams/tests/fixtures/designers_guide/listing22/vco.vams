// Voltage-controlled oscillator
//
// Version 1a, 1 June 04
//
// Ken Kundert
//
// Downloaded from The Designer's Guide Community (www.designers-guide.org).
// Post any questions on www.designers-guide.org/Forum.
// Taken from "The Designer's Guide to Verilog-AMS" by Kundert & Zinke.
// Chapter 3, Listing 22.

`include "disciplines.vams"
`include "constants.vams"

module vco (out, in);
    parameter real Vmin=0;			// minimum input voltage (V)
    parameter real Vmax=Vmin+1 from (Vmin:inf);	// maximum input voltage (V)
    parameter real Fmin=1 from (0:inf);		// minimum output frequency (Hz)
    parameter real Fmax=2*Fmin from (Fmin:inf);	// maximum output frequency (Hz)
    parameter real ampl=1;			// output amplitude (V)
    input in; output out;
    voltage out, in;
    real freq, phase;

    analog begin
	// compute the freq from the input voltage
	freq = (V(in) - Vmin)*(Fmax - Fmin) / (Vmax - Vmin) + Fmin;

	// bound the frequency (this is optional)
	if (freq > Fmax) freq = Fmax;
	if (freq < Fmin) freq = Fmin;

	// phase is the integral of the freq modulo 2p
	phase = 2*`M_PI*idtmod(freq, 0.0, 1.0, -0.5);

	// generate the output
	V(out) <+ sin(phase);

	// bound the time step
	$bound_step(0.1/freq);
    end
endmodule
