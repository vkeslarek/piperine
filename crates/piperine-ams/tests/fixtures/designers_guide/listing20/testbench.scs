// Test barrier model

simulator lang=spectre

ahdl_include "barrier.vams"

Vin  (in 0) vsource type=sine ampl=1 freq=1
Rin  (in n) resistor r=1
B1   (n 0) barrier

setOpts options currents=all useprobes=yes
doTran tran stop=2
