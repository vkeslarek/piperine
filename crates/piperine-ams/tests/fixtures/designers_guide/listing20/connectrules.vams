`include "disciplines.vams"

connectrules my_connectrules;
    connect bidir;
endconnectrules
