// Test circuit for inductor
simulator lang=spectre
include "a01t.scs"

Itest (z 0) isource mag=1
FP    (z 0) a01t

genImpedance ac start=1_Hz stop=100GHz dec=100
// plot the real part of z to see fracpole resistance.
// plot the imaginary part of z to see fracpole reactance.
// plot the magnitude of z to see fracpole impedance.
