// Test circuit for lossy capacitor
simulator lang=spectre
include "lossycap.scs"

Itest (z 0) isource mag=1
FP    (z 0) lossycap

genImpedance ac start=1mHz stop=100MHz dec=100
// plot the real part of z to see fracpole resistance.
// plot the imaginary part of z to see fracpole reactance.
// plot the magnitude of z to see fracpole impedance.
