// Test delay meter

simulator lang=spectre

ahdl_include "time-interval-measurement.vams"

Vin1 (in1 0) vsource type=sine ampl=1 freq=1MHz
Vin2 (in2 0) vsource type=sine ampl=1 freq=1MHz delay=25ns
JM   (in1 in2) time_interval_measurement

doTran tran stop=20us
