// Test delay meter

simulator lang=spectre

ahdl_include "delay_meter.vams"

Vin1 (in1 0) vsource type=sine ampl=1 freq=1MHz
Vin2 (in2 0) vsource type=sine ampl=1 freq=1MHz delay=25ns
JM   (in1 in2) delay_meter

doTran tran stop=20us
