`include "disciplines.vams"

connectrules my_connectrules;
    connect d2a;
endconnectrules
