// Test resistor model

simulator lang=spectre

ahdl_include "motor2.vams"

I1  (0) test

doDC dc print=yes
