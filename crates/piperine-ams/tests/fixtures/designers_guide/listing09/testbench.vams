`timescale 10ps / 1ps

module testbench ();
    reg clk;
    reg [0:7] in;
    integer i,ii;
    wreal out;

    initial begin
	clk=0;
	in=0;
	i=0;
    end

    always #100 clk=~clk;

    always begin
	#333
	wait (!clk);
	in=i;
	i=i+1;
	if (i == 256) i=0;

	for (ii=0; ii<8; ii=ii+1) in[ii] <= in[7-ii];
    end

    dac dac0 (out, in, clk);
endmodule
