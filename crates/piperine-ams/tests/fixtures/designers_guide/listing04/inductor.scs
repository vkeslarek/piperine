// Test inductor model

simulator lang=spectre

ahdl_include "inductor.vams"

Vc (v 0) isource mag=1
L1 (v 0) inductor l=1uF

doAC ac freq=1MHz/(2*M_PI)
