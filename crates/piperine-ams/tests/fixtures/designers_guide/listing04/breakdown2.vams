// Warn on Breakdown
//
// Version 1a, 1 June 04
//
// Ken Kundert
//
// Downloaded from The Designer's Guide Community (www.designers-guide.org).
// Post any questions on www.designers-guide.org/Forum.
// Taken from "The Designer's Guide to Verilog-AMS" by Kundert & Zinke.
// Chapter 5, Listing 4.
//
// This version of breakdown was modified to work in
// version 5.0 of Spectre (May 2003).

`include "disciplines.vams"

module breakdown (n);
    parameter real threshold = 1000.0;	// warning is emitted when this level is exceeded (V)
    input n; voltage n;
    integer given;

    analog begin
	@(above(V(n) - threshold)) begin
	    if (!given) begin
		$strobe("Warning: breakdown voltage exceeded (detected by %m at %gs)\n.",
			$abstime);
		given = 1;
	    end
	end
    end
endmodule
