`include "disciplines.vams"

connectrules my_connectrules;
    connect electrical, voltage resolveto electrical;
endconnectrules
