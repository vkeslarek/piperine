`timescale 10ns / 10ps
`include "disciplines.vams"

module testbench ();
    electrical gnd;
    ground gnd;

    wire out_slow, out_fast;

    vsource #(.type("sine"), .ampl(2.5), .dc(2.5), .freq(1M)) v0 (in_slow, gnd);
    inverter inv0 (out_slow, in_slow);

    vsource #(.type("sine"), .ampl(2.5), .dc(2.5), .freq(20M)) v1 (in_fast, gnd);
    inverter inv1 (out_fast, in_fast);
endmodule
