// Test capacitor model

simulator lang=spectre

ahdl_include "capacitor.vams"

Vc (v 0) vsource mag=1
C1 (v 0) capacitor c=1uF
C2 (x 0) capacitor c=1uF
R1 (x 0) resistor r=1k

save Vc:p x
ic x=1

doAC ac freq=1MHz/(2*M_PI)
doTran tran stop=10ms
