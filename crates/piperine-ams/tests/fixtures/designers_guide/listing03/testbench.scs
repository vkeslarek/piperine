// Test D-flip flop model

simulator lang=spectre

ahdl_include "dff.vams"

Vclk (clk 0) vsource type=pulse val0=0 val1=1 period=10ns
Vd   (d 0) vsource type=pulse val0=0 val1=1 period=33ns
DFF  (q d clk) dff

doTran tran stop=200ns
