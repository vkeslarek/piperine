// Non-ideal logic controlled switch
//
// Version 1a, 1 June 04
//
// Olaf Zinke
//
// Downloaded from The Designer's Guide Community (www.designers-guide.org).
// Post any questions on www.designers-guide.org/Forum.
// Taken from "The Designer's Guide to Verilog-AMS" by Kundert & Zinke.
// Chapter 4, Listing 11.

`timescale 1ns / 1ps
`include "disciplines.vams"

module sw(p, n, s);
    parameter real ron = 10.0 from (0:inf);	// on resistance (ohms)
    parameter real roff = 100.0M from (ron:inf);// off resistance (ohms)
    parameter real td = 0.0;			// delay time (s)
    parameter real tr = 20n;			// rise time (on -> off) (s)
    parameter real tf = 20n;			// fall time (off -> on) (s)
    input s;
    logic s;
    electrical p, n;
    real reff;

    analog begin
	@(posedge s) reff = ron;
	@(negedge s) reff = roff;
	@(initial_step) reff = (s ? ron : roff);
	I(p, n) <+ V(p, n) / transition(reff, td, tr, tf);
    end
endmodule
